* NGSPICE file created from DigitalSine.ext - technology: ihp-sg13g2

* Black-box entry subcircuit for sg13g2_dfrbpq_1 abstract view
.subckt sg13g2_dfrbpq_1 Q CLK D RESET_B VDD VSS
.ends

* Black-box entry subcircuit for sg13g2_inv_1 abstract view
.subckt sg13g2_inv_1 Y A VDD VSS
.ends

* Black-box entry subcircuit for sg13g2_o21ai_1 abstract view
.subckt sg13g2_o21ai_1 Y A1 A2 B1 VDD VSS
.ends

* Black-box entry subcircuit for sg13g2_nand3_1 abstract view
.subckt sg13g2_nand3_1 Y A B C VDD VSS
.ends

* Black-box entry subcircuit for sg13g2_decap_8 abstract view
.subckt sg13g2_decap_8 VDD VSS
.ends

* Black-box entry subcircuit for sg13g2_buf_1 abstract view
.subckt sg13g2_buf_1 X A VDD VSS
.ends

* Black-box entry subcircuit for sg13g2_nand2b_1 abstract view
.subckt sg13g2_nand2b_1 Y A_N B VDD VSS
.ends

* Black-box entry subcircuit for sg13g2_fill_2 abstract view
.subckt sg13g2_fill_2 VDD VSS
.ends

* Black-box entry subcircuit for sg13g2_nor2_1 abstract view
.subckt sg13g2_nor2_1 Y A B VDD VSS
.ends

* Black-box entry subcircuit for sg13g2_fill_1 abstract view
.subckt sg13g2_fill_1 VDD VSS
.ends

* Black-box entry subcircuit for sg13g2_nor3_1 abstract view
.subckt sg13g2_nor3_1 Y A B C VDD VSS
.ends

* Black-box entry subcircuit for sg13g2_dlygate4sd3_1 abstract view
.subckt sg13g2_dlygate4sd3_1 X A VDD VSS
.ends

* Black-box entry subcircuit for sg13g2_nand2_1 abstract view
.subckt sg13g2_nand2_1 Y A B VDD VSS
.ends

* Black-box entry subcircuit for sg13g2_and2_1 abstract view
.subckt sg13g2_and2_1 X A B VDD VSS
.ends

* Black-box entry subcircuit for sg13g2_xnor2_1 abstract view
.subckt sg13g2_xnor2_1 Y A B VDD VSS
.ends

* Black-box entry subcircuit for sg13g2_a21oi_1 abstract view
.subckt sg13g2_a21oi_1 Y A1 A2 B1 VDD VSS
.ends

* Black-box entry subcircuit for sg13g2_xor2_1 abstract view
.subckt sg13g2_xor2_1 X A B VDD VSS
.ends

* Black-box entry subcircuit for sg13g2_decap_4 abstract view
.subckt sg13g2_decap_4 VDD VSS
.ends

* Black-box entry subcircuit for sg13g2_nor2b_1 abstract view
.subckt sg13g2_nor2b_1 Y A B_N VDD VSS
.ends

* Black-box entry subcircuit for sg13g2_buf_16 abstract view
.subckt sg13g2_buf_16 X A VDD VSS
.ends

* Black-box entry subcircuit for sg13g2_a21o_1 abstract view
.subckt sg13g2_a21o_1 X A1 A2 B1 VDD VSS
.ends

* Black-box entry subcircuit for sg13g2_or4_1 abstract view
.subckt sg13g2_or4_1 X A B C D VDD VSS
.ends

* Black-box entry subcircuit for sg13g2_a221oi_1 abstract view
.subckt sg13g2_a221oi_1 Y A1 A2 B1 B2 C1 VDD VSS
.ends

* Black-box entry subcircuit for sg13g2_a22oi_1 abstract view
.subckt sg13g2_a22oi_1 Y A1 A2 B1 B2 VDD VSS
.ends

* Black-box entry subcircuit for sg13g2_nand4_1 abstract view
.subckt sg13g2_nand4_1 Y A B C D VDD VSS
.ends

* Black-box entry subcircuit for sg13g2_nor4_1 abstract view
.subckt sg13g2_nor4_1 Y A B C D VDD VSS
.ends

* Black-box entry subcircuit for sg13g2_nand3b_1 abstract view
.subckt sg13g2_nand3b_1 Y A_N B C VDD VSS
.ends

* Black-box entry subcircuit for sg13g2_or2_1 abstract view
.subckt sg13g2_or2_1 X A B VDD VSS
.ends

.subckt DigitalSine VGND VPWR clk rst sign signB sine_out[0] sine_out[10] sine_out[11]
+ sine_out[12] sine_out[13] sine_out[14] sine_out[15] sine_out[16] sine_out[17] sine_out[1]
+ sine_out[2] sine_out[3] sine_out[4] sine_out[5] sine_out[6] sine_out[7] sine_out[8]
+ sine_out[9]
X_294_ _294_/Q _296_/CLK _294_/D _287_/Y VPWR VGND sg13g2_dfrbpq_1
X_131_ _178_/A _188_/A VPWR VGND sg13g2_inv_1
X_200_ _200_/Y _189_/A _206_/B _199_/Y VPWR VGND sg13g2_o21ai_1
X_277_ _277_/Y _277_/A _294_/Q _277_/C VPWR VGND sg13g2_nand3_1
XFILLER_11_0 VPWR VGND sg13g2_decap_8
Xoutput7 sine_out[12] _271_/Y VPWR VGND sg13g2_buf_1
Xoutput20 sine_out[8] _264_/Y VPWR VGND sg13g2_buf_1
X_293_ _293_/Q _296_/CLK _293_/D _286_/Y VPWR VGND sg13g2_dfrbpq_1
X_130_ _169_/A _274_/A VPWR VGND sg13g2_inv_1
X_276_ _277_/C _290_/Q _276_/B VPWR VGND sg13g2_nand2b_1
XFILLER_9_23 VPWR VGND sg13g2_fill_2
X_259_ _260_/C _288_/D _259_/B VPWR VGND sg13g2_nor2_1
XFILLER_6_35 VPWR VGND sg13g2_fill_1
Xoutput8 sine_out[13] _272_/Y VPWR VGND sg13g2_buf_1
Xoutput21 sine_out[9] _265_/Y VPWR VGND sg13g2_buf_1
Xoutput10 sine_out[15] _274_/Y VPWR VGND sg13g2_buf_1
XFILLER_3_14 VPWR VGND sg13g2_fill_1
X_292_ _292_/Q _292_/CLK _292_/D _285_/Y VPWR VGND sg13g2_dfrbpq_1
XFILLER_9_35 VPWR VGND sg13g2_fill_2
XFILLER_9_46 VPWR VGND sg13g2_fill_2
X_189_ _189_/Y _189_/A _189_/B _189_/C VPWR VGND sg13g2_nor3_1
X_275_ _275_/Y _277_/A _270_/Y _269_/A VPWR VGND sg13g2_o21ai_1
X_258_ _258_/Y _274_/A _258_/B _258_/C VPWR VGND sg13g2_nor3_1
XFILLER_1_0 VPWR VGND sg13g2_fill_2
XFILLER_6_25 VPWR VGND sg13g2_fill_1
Xhold43 _163_/A _295_/Q VPWR VGND sg13g2_dlygate4sd3_1
Xoutput9 sine_out[14] _273_/Y VPWR VGND sg13g2_buf_1
Xoutput11 sine_out[16] _275_/Y VPWR VGND sg13g2_buf_1
X_291_ _291_/Q _292_/CLK _291_/D _284_/Y VPWR VGND sg13g2_dfrbpq_1
X_274_ _274_/Y _274_/A _274_/B VPWR VGND sg13g2_nand2_1
X_188_ _189_/C _188_/A _206_/B VPWR VGND sg13g2_and2_1
X_257_ _257_/Y _257_/A _272_/A VPWR VGND sg13g2_nor2_1
Xoutput12 sine_out[17] _277_/Y VPWR VGND sg13g2_buf_1
X_290_ _290_/Q _292_/CLK _290_/D _283_/Y VPWR VGND sg13g2_dfrbpq_1
XFILLER_2_114 VPWR VGND sg13g2_fill_1
X_187_ _206_/B _187_/A _279_/A VPWR VGND sg13g2_xnor2_1
X_273_ _273_/Y _274_/A _273_/B VPWR VGND sg13g2_nand2_1
X_256_ _256_/Y _274_/A _273_/B VPWR VGND sg13g2_nor2_1
X_239_ _239_/Y _239_/A _239_/B _239_/C VPWR VGND sg13g2_nor3_1
Xclkload0 clkload0/Y _296_/CLK VPWR VGND sg13g2_inv_1
XFILLER_13_7 VPWR VGND sg13g2_decap_8
Xoutput13 sine_out[1] _235_/Y VPWR VGND sg13g2_buf_1
X_272_ _272_/Y _272_/A _272_/B VPWR VGND sg13g2_nor2_1
X_186_ _239_/C _184_/A _288_/D _178_/A VPWR VGND sg13g2_a21oi_1
X_255_ _273_/B _255_/A _255_/B VPWR VGND sg13g2_nand2_1
XFILLER_10_81 VPWR VGND sg13g2_decap_8
X_169_ _169_/Y _169_/A _179_/A VPWR VGND sg13g2_nor2_1
X_238_ _238_/X _238_/A _238_/B VPWR VGND sg13g2_xor2_1
XFILLER_7_60 VPWR VGND sg13g2_decap_4
Xoutput14 sine_out[2] _253_/Y VPWR VGND sg13g2_buf_1
X_185_ _189_/B _188_/A _241_/C VPWR VGND sg13g2_nor2_1
X_271_ _271_/Y _277_/A _270_/Y _269_/A VPWR VGND sg13g2_a21oi_1
X_254_ _254_/Y _276_/B _255_/B VPWR VGND sg13g2_nand2_1
X_168_ _272_/B _259_/B _232_/A VPWR VGND sg13g2_nor2_1
X_237_ _238_/B _239_/C _237_/B VPWR VGND sg13g2_nor2_1
Xoutput15 sine_out[3] _256_/Y VPWR VGND sg13g2_buf_1
X_270_ _270_/Y _270_/A _292_/Q VPWR VGND sg13g2_nor2b_1
X_184_ _241_/C _184_/A _279_/A VPWR VGND sg13g2_nor2_1
X_253_ _253_/Y _269_/A _245_/Y _252_/Y VPWR VGND sg13g2_o21ai_1
X_167_ _232_/A _213_/A _261_/A VPWR VGND sg13g2_nand2_1
X_219_ _234_/B _217_/Y _218_/X _172_/Y VPWR VGND sg13g2_a21oi_1
X_236_ _237_/B _257_/A _279_/A _236_/C VPWR VGND sg13g2_nor3_1
XFILLER_11_7 VPWR VGND sg13g2_fill_2
Xoutput16 sine_out[4] _258_/Y VPWR VGND sg13g2_buf_1
Xclkbuf_0_clk clkbuf_0_clk/X clk VPWR VGND sg13g2_buf_16
XFILLER_12_29 VPWR VGND sg13g2_fill_1
XFILLER_13_83 VPWR VGND sg13g2_fill_2
XFILLER_9_19 VPWR VGND sg13g2_decap_4
X_166_ _259_/B _239_/A _241_/B VPWR VGND sg13g2_nand2_1
X_183_ _198_/B _177_/Y _182_/Y _172_/Y VPWR VGND sg13g2_a21oi_1
X_235_ _235_/Y _169_/A _233_/Y _234_/X VPWR VGND sg13g2_o21ai_1
Xfanout40 _179_/A _279_/A VPWR VGND sg13g2_buf_1
X_252_ _252_/Y _247_/Y _252_/B VPWR VGND sg13g2_nand2b_1
X_149_ _149_/Y _162_/A _277_/A VPWR VGND sg13g2_nand2_1
X_218_ _218_/X _165_/Y _206_/B _238_/A VPWR VGND sg13g2_a21o_1
Xoutput17 sine_out[5] _260_/Y VPWR VGND sg13g2_buf_1
XFILLER_7_41 VPWR VGND sg13g2_fill_2
XFILLER_7_96 VPWR VGND sg13g2_fill_2
XFILLER_13_62 VPWR VGND sg13g2_decap_8
XFILLER_4_86 VPWR VGND sg13g2_fill_2
XFILLER_8_0 VPWR VGND sg13g2_decap_8
X_182_ _182_/Y _279_/A _236_/C _181_/X VPWR VGND sg13g2_o21ai_1
Xfanout41 _279_/A _288_/Q VPWR VGND sg13g2_buf_1
Xfanout30 _213_/A _292_/Q VPWR VGND sg13g2_buf_1
X_251_ _252_/B _213_/A _181_/X _250_/Y VPWR VGND sg13g2_a21oi_1
XFILLER_10_63 VPWR VGND sg13g2_decap_4
XFILLER_10_74 VPWR VGND sg13g2_decap_8
XFILLER_10_96 VPWR VGND sg13g2_fill_1
X_148_ _151_/A _147_/A _147_/B _145_/X VPWR VGND sg13g2_a21oi_1
X_165_ _165_/Y _188_/A _187_/A VPWR VGND sg13g2_nand2_1
X_217_ _217_/Y _189_/B _189_/C _238_/A VPWR VGND sg13g2_o21ai_1
X_234_ _234_/X _274_/A _234_/B _234_/C _234_/D VPWR VGND sg13g2_or4_1
XFILLER_7_53 VPWR VGND sg13g2_decap_8
Xoutput18 sine_out[6] _262_/Y VPWR VGND sg13g2_buf_1
XFILLER_8_114 VPWR VGND sg13g2_fill_1
XFILLER_13_30 VPWR VGND sg13g2_decap_8
XFILLER_13_85 VPWR VGND sg13g2_fill_1
XFILLER_1_55 VPWR VGND sg13g2_fill_1
X_164_ _241_/B _188_/A _187_/A VPWR VGND sg13g2_and2_1
X_181_ _181_/X _229_/A _270_/A VPWR VGND sg13g2_and2_1
X_233_ _233_/Y _290_/Q _204_/Y _226_/Y _231_/Y _232_/Y VPWR VGND sg13g2_a221oi_1
Xfanout42 _286_/A _287_/A VPWR VGND sg13g2_buf_1
Xfanout31 _257_/A _292_/Q VPWR VGND sg13g2_buf_1
X_250_ _250_/Y _269_/A _250_/B _250_/C VPWR VGND sg13g2_nand3_1
X_147_ _292_/D _147_/A _147_/B VPWR VGND sg13g2_xor2_1
X_216_ _216_/Y _193_/Y _198_/Y _200_/Y _215_/Y VPWR VGND sg13g2_a22oi_1
Xoutput19 sine_out[7] _263_/Y VPWR VGND sg13g2_buf_1
XFILLER_7_43 VPWR VGND sg13g2_fill_1
X_180_ _270_/A _179_/A _241_/B _238_/A VPWR VGND sg13g2_a21oi_1
Xfanout32 _189_/A _248_/B VPWR VGND sg13g2_buf_1
X_163_ _295_/D _163_/A _171_/A VPWR VGND sg13g2_xnor2_1
X_232_ _232_/Y _232_/A _232_/B VPWR VGND sg13g2_nor2_1
X_146_ _147_/B _146_/A _257_/A VPWR VGND sg13g2_xor2_1
X_215_ _215_/Y _204_/Y _205_/Y _214_/Y VPWR VGND sg13g2_a21oi_1
XFILLER_13_76 VPWR VGND sg13g2_decap_8
XFILLER_6_0 VPWR VGND sg13g2_decap_8
X_162_ _171_/A _162_/A _169_/A _162_/C _255_/A VPWR VGND sg13g2_nand4_1
X_231_ _231_/Y _199_/A _230_/Y _228_/Y VPWR VGND sg13g2_o21ai_1
Xfanout33 _238_/A _239_/A VPWR VGND sg13g2_buf_1
Xfanout22 _258_/B _260_/B VPWR VGND sg13g2_buf_1
XFILLER_1_68 VPWR VGND sg13g2_fill_1
X_145_ _145_/X _146_/A _257_/A VPWR VGND sg13g2_and2_1
X_214_ _214_/Y _274_/A _214_/B _214_/C VPWR VGND sg13g2_nand3_1
Xinput1 _287_/A rst VPWR VGND sg13g2_buf_1
XFILLER_13_44 VPWR VGND sg13g2_decap_8
XFILLER_13_55 VPWR VGND sg13g2_decap_8
Xfanout34 _239_/A _248_/B VPWR VGND sg13g2_buf_1
Xfanout23 _146_/A _296_/Q VPWR VGND sg13g2_buf_1
XFILLER_10_45 VPWR VGND sg13g2_decap_4
XFILLER_10_67 VPWR VGND sg13g2_fill_2
X_161_ _255_/A _189_/A _258_/B VPWR VGND sg13g2_nor2_1
X_230_ _230_/Y _270_/A _230_/B VPWR VGND sg13g2_xnor2_1
X_144_ _147_/A _143_/A _143_/B _141_/Y VPWR VGND sg13g2_o21ai_1
X_213_ _214_/C _213_/A _261_/A _213_/C _232_/B VPWR VGND sg13g2_nand4_1
XFILLER_12_114 VPWR VGND sg13g2_fill_1
XFILLER_13_23 VPWR VGND sg13g2_decap_8
Xfanout35 _248_/B _291_/Q VPWR VGND sg13g2_buf_1
Xfanout24 _162_/A _296_/Q VPWR VGND sg13g2_buf_1
XFILLER_10_35 VPWR VGND sg13g2_decap_4
X_143_ _291_/D _143_/A _143_/B VPWR VGND sg13g2_xor2_1
X_160_ _276_/B _239_/A _213_/A VPWR VGND sg13g2_nor2_1
X_212_ _232_/B _178_/A _288_/D _211_/A VPWR VGND sg13g2_o21ai_1
X_289_ _289_/Q _292_/CLK _289_/D _282_/Y VPWR VGND sg13g2_dfrbpq_1
Xfanout36 _187_/A _184_/A VPWR VGND sg13g2_buf_1
Xfanout25 _274_/A _294_/Q VPWR VGND sg13g2_buf_1
X_288_ _288_/Q _292_/CLK _288_/D _281_/Y VPWR VGND sg13g2_dfrbpq_1
XFILLER_4_0 VPWR VGND sg13g2_fill_2
XFILLER_7_26 VPWR VGND sg13g2_fill_2
X_142_ _143_/B _146_/A _189_/A VPWR VGND sg13g2_xnor2_1
X_211_ _211_/Y _211_/A VPWR VGND sg13g2_inv_1
XFILLER_13_14 VPWR VGND sg13g2_decap_4
XFILLER_13_69 VPWR VGND sg13g2_decap_8
XFILLER_1_104 VPWR VGND sg13g2_fill_2
XFILLER_5_81 VPWR VGND sg13g2_fill_2
XFILLER_8_7 VPWR VGND sg13g2_decap_4
Xfanout37 _184_/A _290_/Q VPWR VGND sg13g2_buf_1
Xfanout26 _269_/A _272_/A VPWR VGND sg13g2_buf_1
X_141_ _141_/Y _146_/A _189_/A VPWR VGND sg13g2_nand2_1
X_210_ _211_/A _239_/A _290_/Q VPWR VGND sg13g2_nor2_1
X_287_ _287_/Y _287_/A VPWR VGND sg13g2_inv_1
XFILLER_12_0 VPWR VGND sg13g2_decap_8
XFILLER_8_81 VPWR VGND sg13g2_fill_1
Xfanout38 _188_/A _205_/B VPWR VGND sg13g2_buf_1
Xfanout27 _272_/A _294_/Q VPWR VGND sg13g2_buf_1
XFILLER_13_37 VPWR VGND sg13g2_decap_8
XFILLER_1_18 VPWR VGND sg13g2_fill_2
X_286_ _286_/Y _286_/A VPWR VGND sg13g2_inv_1
XFILLER_10_49 VPWR VGND sg13g2_fill_1
X_140_ _143_/A _278_/A _278_/B _135_/X VPWR VGND sg13g2_a21oi_1
X_269_ _269_/Y _269_/A _269_/B VPWR VGND sg13g2_nor2_1
XFILLER_11_70 VPWR VGND sg13g2_fill_1
XFILLER_11_81 VPWR VGND sg13g2_fill_1
XFILLER_7_28 VPWR VGND sg13g2_fill_1
Xfanout39 _205_/B _289_/Q VPWR VGND sg13g2_buf_1
Xfanout28 _261_/A _277_/A VPWR VGND sg13g2_buf_1
XFILLER_10_28 VPWR VGND sg13g2_decap_8
XFILLER_10_39 VPWR VGND sg13g2_fill_2
X_285_ _285_/Y _286_/A VPWR VGND sg13g2_inv_1
XFILLER_2_0 VPWR VGND sg13g2_fill_2
X_199_ _199_/Y _199_/A _177_/Y VPWR VGND sg13g2_nor2b_1
X_268_ _269_/B _173_/Y _211_/A _232_/A VPWR VGND sg13g2_a21oi_1
XFILLER_4_19 VPWR VGND sg13g2_fill_2
XFILLER_6_7 VPWR VGND sg13g2_fill_1
Xfanout29 _277_/A _293_/Q VPWR VGND sg13g2_buf_1
X_284_ _284_/Y _286_/A VPWR VGND sg13g2_inv_1
XFILLER_2_85 VPWR VGND sg13g2_fill_2
X_198_ _198_/Y _272_/A _198_/B _198_/C _198_/D VPWR VGND sg13g2_nor4_1
X_267_ _267_/Y _267_/A _267_/B VPWR VGND sg13g2_nand2_1
Xclkbuf_1_0__f_clk _292_/CLK clkbuf_0_clk/X VPWR VGND sg13g2_buf_16
XFILLER_10_0 VPWR VGND sg13g2_fill_2
X_283_ _283_/Y _286_/A VPWR VGND sg13g2_inv_1
X_197_ _198_/D _259_/B _175_/Y _199_/A VPWR VGND sg13g2_a21oi_1
X_266_ _267_/B _241_/C _241_/D _257_/Y VPWR VGND sg13g2_o21ai_1
X_249_ _250_/C _213_/A _211_/A _261_/A VPWR VGND sg13g2_o21ai_1
X_196_ _199_/A _261_/A _257_/A VPWR VGND sg13g2_nand2b_1
X_282_ _282_/Y _286_/A VPWR VGND sg13g2_inv_1
X_265_ _265_/Y _277_/A _254_/Y _269_/A VPWR VGND sg13g2_a21oi_1
XFILLER_0_0 VPWR VGND sg13g2_fill_2
XFILLER_11_63 VPWR VGND sg13g2_decap_8
X_179_ _227_/B _179_/A _241_/B VPWR VGND sg13g2_nand2_1
X_248_ _250_/B _255_/B _248_/B _258_/B VPWR VGND sg13g2_nand3b_1
XFILLER_8_64 VPWR VGND sg13g2_fill_2
X_281_ _281_/Y _286_/A VPWR VGND sg13g2_inv_1
XFILLER_11_31 VPWR VGND sg13g2_fill_1
XFILLER_11_42 VPWR VGND sg13g2_fill_2
XFILLER_11_75 VPWR VGND sg13g2_fill_2
X_195_ _198_/C _239_/A _178_/A _270_/A _227_/C _258_/B VPWR VGND sg13g2_a221oi_1
X_247_ _247_/Y _213_/C _230_/B _274_/B VPWR VGND sg13g2_a21oi_1
X_264_ _264_/Y _213_/A _260_/C _267_/A VPWR VGND sg13g2_a21oi_1
X_178_ _236_/C _178_/A _187_/A VPWR VGND sg13g2_nand2_1
XFILLER_5_22 VPWR VGND sg13g2_fill_1
XFILLER_2_23 VPWR VGND sg13g2_fill_2
X_194_ _227_/C _173_/Y _194_/B VPWR VGND sg13g2_nand2b_1
X_280_ _280_/Y _286_/A VPWR VGND sg13g2_inv_1
X_263_ _263_/Y _213_/A _258_/C _267_/A VPWR VGND sg13g2_a21oi_1
XFILLER_11_21 VPWR VGND sg13g2_fill_1
X_177_ _177_/Y _176_/Y _238_/A VPWR VGND sg13g2_nand2b_1
X_246_ _274_/B _258_/B _259_/B VPWR VGND sg13g2_nand2b_1
XFILLER_12_7 VPWR VGND sg13g2_fill_2
XFILLER_8_11 VPWR VGND sg13g2_fill_2
XFILLER_8_66 VPWR VGND sg13g2_fill_1
X_229_ _230_/B _229_/A _255_/B VPWR VGND sg13g2_nand2_1
XFILLER_11_44 VPWR VGND sg13g2_fill_1
X_193_ _193_/Y _189_/Y _193_/B VPWR VGND sg13g2_nand2b_1
X_262_ _262_/Y _213_/A _211_/Y _267_/A VPWR VGND sg13g2_a21oi_1
X_159_ _260_/B _292_/Q _277_/A VPWR VGND sg13g2_or2_1
X_176_ _176_/Y _179_/A _201_/A _175_/A _184_/A VPWR VGND sg13g2_a22oi_1
X_228_ _228_/Y _258_/B _228_/B VPWR VGND sg13g2_nand2b_1
X_245_ _245_/Y _261_/A _238_/X _244_/Y VPWR VGND sg13g2_o21ai_1
X_192_ _193_/B _189_/A _191_/Y _232_/A VPWR VGND sg13g2_a21oi_1
X_261_ _267_/A _261_/A _269_/A VPWR VGND sg13g2_or2_1
XFILLER_9_0 VPWR VGND sg13g2_decap_8
X_175_ _175_/Y _175_/A VPWR VGND sg13g2_inv_1
X_244_ _244_/Y _239_/Y _240_/Y _243_/Y VPWR VGND sg13g2_o21ai_1
X_158_ _162_/C _288_/D _229_/A VPWR VGND sg13g2_nor2_1
X_227_ _228_/B _239_/A _227_/B _227_/C VPWR VGND sg13g2_nand3_1
XFILLER_5_69 VPWR VGND sg13g2_fill_2
Xclkbuf_1_1__f_clk _296_/CLK clkbuf_0_clk/X VPWR VGND sg13g2_buf_16
XFILLER_6_90 VPWR VGND sg13g2_fill_1
X_191_ _191_/Y _288_/D _201_/A VPWR VGND sg13g2_xnor2_1
X_260_ _260_/Y _269_/A _260_/B _260_/C VPWR VGND sg13g2_nor3_1
XFILLER_8_47 VPWR VGND sg13g2_fill_2
X_157_ _229_/A _201_/A VPWR VGND sg13g2_inv_1
X_174_ _175_/A _205_/B _179_/A VPWR VGND sg13g2_xnor2_1
X_226_ _226_/Y _201_/A _175_/A _276_/B VPWR VGND sg13g2_o21ai_1
X_243_ _243_/Y _276_/B _230_/B _242_/Y VPWR VGND sg13g2_a21oi_1
XFILLER_3_101 VPWR VGND sg13g2_fill_2
XFILLER_5_26 VPWR VGND sg13g2_fill_1
X_209_ _213_/C _179_/A _229_/A _239_/A VPWR VGND sg13g2_o21ai_1
XFILLER_11_36 VPWR VGND sg13g2_fill_1
X_173_ _173_/Y _205_/B _179_/A VPWR VGND sg13g2_nor2_1
X_190_ _194_/B _205_/B _184_/A _279_/A VPWR VGND sg13g2_o21ai_1
X_242_ _242_/Y _241_/Y _261_/A VPWR VGND sg13g2_nand2b_1
XFILLER_12_90 VPWR VGND sg13g2_fill_1
X_156_ _201_/A _205_/B _184_/A VPWR VGND sg13g2_nor2_1
X_225_ _234_/D _189_/C _224_/Y _223_/Y VPWR VGND sg13g2_o21ai_1
XFILLER_9_80 VPWR VGND sg13g2_fill_2
X_139_ _278_/B _146_/A _187_/A VPWR VGND sg13g2_xor2_1
X_208_ _214_/B _248_/B _191_/Y _207_/Y VPWR VGND sg13g2_o21ai_1
XFILLER_7_0 VPWR VGND sg13g2_decap_4
XFILLER_8_49 VPWR VGND sg13g2_fill_1
X_155_ _239_/B _187_/A _288_/D VPWR VGND sg13g2_nor2_1
X_172_ _172_/Y _257_/A _261_/A VPWR VGND sg13g2_nand2b_1
X_224_ _224_/Y _199_/A _236_/C VPWR VGND sg13g2_nand2b_1
X_241_ _241_/Y _257_/A _241_/B _241_/C _241_/D VPWR VGND sg13g2_nor4_1
X_138_ _278_/A _288_/D _279_/B _136_/Y VPWR VGND sg13g2_o21ai_1
X_207_ _207_/Y _248_/B _206_/B _258_/B VPWR VGND sg13g2_a21oi_1
XFILLER_11_27 VPWR VGND sg13g2_decap_4
X_171_ _296_/D _171_/A _171_/B VPWR VGND sg13g2_and2_1
X_240_ _240_/Y _241_/B _241_/D _257_/A VPWR VGND sg13g2_o21ai_1
X_154_ _294_/D _154_/A _154_/B VPWR VGND sg13g2_xnor2_1
X_223_ _223_/Y _187_/A _205_/Y _206_/Y VPWR VGND sg13g2_o21ai_1
XFILLER_5_18 VPWR VGND sg13g2_fill_1
XFILLER_9_82 VPWR VGND sg13g2_fill_1
X_137_ _279_/B _146_/A _188_/A VPWR VGND sg13g2_xnor2_1
X_206_ _206_/Y _258_/B _206_/B VPWR VGND sg13g2_nor2_1
XFILLER_11_17 VPWR VGND sg13g2_decap_4
XFILLER_3_95 VPWR VGND sg13g2_fill_2
X_170_ _171_/B _272_/B _169_/Y _162_/A VPWR VGND sg13g2_a21o_1
XFILLER_0_52 VPWR VGND sg13g2_fill_1
X_136_ _136_/Y _146_/A _188_/A VPWR VGND sg13g2_nand2_1
X_153_ _154_/B _162_/A _274_/A VPWR VGND sg13g2_xnor2_1
X_205_ _205_/Y _189_/A _205_/B VPWR VGND sg13g2_nand2b_1
X_222_ _234_/C _232_/A _222_/B VPWR VGND sg13g2_nor2_1
Xoutput2 sign _295_/Q VPWR VGND sg13g2_buf_1
XFILLER_12_83 VPWR VGND sg13g2_decap_8
XFILLER_5_0 VPWR VGND sg13g2_fill_1
X_152_ _154_/A _151_/A _151_/B _149_/Y VPWR VGND sg13g2_o21ai_1
X_221_ _222_/B _238_/A _176_/Y _220_/Y VPWR VGND sg13g2_o21ai_1
XFILLER_9_62 VPWR VGND sg13g2_decap_8
XFILLER_9_73 VPWR VGND sg13g2_fill_2
X_135_ _135_/X _146_/A _187_/A VPWR VGND sg13g2_and2_1
X_204_ _204_/Y _258_/C _255_/B _172_/Y VPWR VGND sg13g2_a21oi_1
XFILLER_7_4 VPWR VGND sg13g2_fill_1
XFILLER_9_101 VPWR VGND sg13g2_fill_1
Xoutput3 signB _133_/Y VPWR VGND sg13g2_buf_1
XFILLER_12_40 VPWR VGND sg13g2_fill_2
X_134_ _134_/Y _286_/A VPWR VGND sg13g2_inv_1
X_151_ _293_/D _151_/A _151_/B VPWR VGND sg13g2_xor2_1
X_203_ _255_/B _205_/B _179_/A _184_/A VPWR VGND sg13g2_o21ai_1
X_220_ _220_/Y _188_/A _241_/C _238_/A VPWR VGND sg13g2_o21ai_1
XFILLER_13_0 VPWR VGND sg13g2_decap_8
XFILLER_6_31 VPWR VGND sg13g2_decap_4
Xoutput4 sine_out[0] _216_/Y VPWR VGND sg13g2_buf_1
X_150_ _151_/B _162_/A _277_/A VPWR VGND sg13g2_xnor2_1
X_296_ _296_/Q _296_/CLK _296_/D _280_/Y VPWR VGND sg13g2_dfrbpq_1
X_279_ _289_/D _279_/A _279_/B VPWR VGND sg13g2_xnor2_1
XFILLER_9_75 VPWR VGND sg13g2_fill_1
X_133_ _133_/Y _295_/Q VPWR VGND sg13g2_inv_1
X_202_ _241_/D _205_/B _184_/A _238_/A VPWR VGND sg13g2_o21ai_1
XFILLER_6_21 VPWR VGND sg13g2_decap_4
XFILLER_6_65 VPWR VGND sg13g2_fill_1
XFILLER_3_55 VPWR VGND sg13g2_fill_2
Xoutput5 sine_out[10] _267_/Y VPWR VGND sg13g2_buf_1
X_295_ _295_/Q _296_/CLK _295_/D _134_/Y VPWR VGND sg13g2_dfrbpq_1
XFILLER_10_102 VPWR VGND sg13g2_fill_1
XFILLER_12_42 VPWR VGND sg13g2_fill_1
XFILLER_3_0 VPWR VGND sg13g2_fill_2
X_132_ _288_/D _279_/A VPWR VGND sg13g2_inv_1
X_201_ _258_/C _201_/A _189_/A VPWR VGND sg13g2_nor2b_1
X_278_ _290_/D _278_/A _278_/B VPWR VGND sg13g2_xor2_1
XFILLER_6_77 VPWR VGND sg13g2_fill_1
Xoutput6 sine_out[11] _269_/Y VPWR VGND sg13g2_buf_1
.ends
