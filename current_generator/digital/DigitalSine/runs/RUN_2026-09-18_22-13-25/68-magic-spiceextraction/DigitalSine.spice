* NGSPICE file created from DigitalSine.ext - technology: ihp-sg13g2

* Black-box entry subcircuit for sg13g2_dfrbpq_1 abstract view
.subckt sg13g2_dfrbpq_1 Q CLK D RESET_B VDD VSS
.ends

* Black-box entry subcircuit for sg13g2_fill_1 abstract view
.subckt sg13g2_fill_1 VDD VSS
.ends

* Black-box entry subcircuit for sg13g2_inv_1 abstract view
.subckt sg13g2_inv_1 Y A VDD VSS
.ends

* Black-box entry subcircuit for sg13g2_o21ai_1 abstract view
.subckt sg13g2_o21ai_1 Y A1 A2 B1 VDD VSS
.ends

* Black-box entry subcircuit for sg13g2_nand3_1 abstract view
.subckt sg13g2_nand3_1 Y A B C VDD VSS
.ends

* Black-box entry subcircuit for sg13g2_decap_8 abstract view
.subckt sg13g2_decap_8 VDD VSS
.ends

* Black-box entry subcircuit for sg13g2_buf_1 abstract view
.subckt sg13g2_buf_1 X A VDD VSS
.ends

* Black-box entry subcircuit for sg13g2_nand2b_1 abstract view
.subckt sg13g2_nand2b_1 Y A_N B VDD VSS
.ends

* Black-box entry subcircuit for sg13g2_fill_2 abstract view
.subckt sg13g2_fill_2 VDD VSS
.ends

* Black-box entry subcircuit for sg13g2_nor2_1 abstract view
.subckt sg13g2_nor2_1 Y A B VDD VSS
.ends

* Black-box entry subcircuit for sg13g2_nor3_1 abstract view
.subckt sg13g2_nor3_1 Y A B C VDD VSS
.ends

* Black-box entry subcircuit for sg13g2_dlygate4sd3_1 abstract view
.subckt sg13g2_dlygate4sd3_1 X A VDD VSS
.ends

* Black-box entry subcircuit for sg13g2_nand2_1 abstract view
.subckt sg13g2_nand2_1 Y A B VDD VSS
.ends

* Black-box entry subcircuit for sg13g2_and2_1 abstract view
.subckt sg13g2_and2_1 X A B VDD VSS
.ends

* Black-box entry subcircuit for sg13g2_xnor2_1 abstract view
.subckt sg13g2_xnor2_1 Y A B VDD VSS
.ends

* Black-box entry subcircuit for sg13g2_a21oi_1 abstract view
.subckt sg13g2_a21oi_1 Y A1 A2 B1 VDD VSS
.ends

* Black-box entry subcircuit for sg13g2_xor2_1 abstract view
.subckt sg13g2_xor2_1 X A B VDD VSS
.ends

* Black-box entry subcircuit for sg13g2_nor2b_1 abstract view
.subckt sg13g2_nor2b_1 Y A B_N VDD VSS
.ends

* Black-box entry subcircuit for sg13g2_buf_16 abstract view
.subckt sg13g2_buf_16 X A VDD VSS
.ends

* Black-box entry subcircuit for sg13g2_decap_4 abstract view
.subckt sg13g2_decap_4 VDD VSS
.ends

* Black-box entry subcircuit for sg13g2_a21o_1 abstract view
.subckt sg13g2_a21o_1 X A1 A2 B1 VDD VSS
.ends

* Black-box entry subcircuit for sg13g2_or4_1 abstract view
.subckt sg13g2_or4_1 X A B C D VDD VSS
.ends

* Black-box entry subcircuit for sg13g2_a221oi_1 abstract view
.subckt sg13g2_a221oi_1 Y A1 A2 B1 B2 C1 VDD VSS
.ends

* Black-box entry subcircuit for sg13g2_a22oi_1 abstract view
.subckt sg13g2_a22oi_1 Y A1 A2 B1 B2 VDD VSS
.ends

* Black-box entry subcircuit for sg13g2_nand4_1 abstract view
.subckt sg13g2_nand4_1 Y A B C D VDD VSS
.ends

* Black-box entry subcircuit for sg13g2_nor4_1 abstract view
.subckt sg13g2_nor4_1 Y A B C D VDD VSS
.ends

* Black-box entry subcircuit for sg13g2_nand3b_1 abstract view
.subckt sg13g2_nand3b_1 Y A_N B C VDD VSS
.ends

* Black-box entry subcircuit for sg13g2_or2_1 abstract view
.subckt sg13g2_or2_1 X A B VDD VSS
.ends

.subckt DigitalSine DATA[0] DATA[10] DATA[11] DATA[12] DATA[13] DATA[14] DATA[15]
+ DATA[16] DATA[17] DATA[1] DATA[2] DATA[3] DATA[4] DATA[5] DATA[6] DATA[7] DATA[8]
+ DATA[9] DVDD DVSS clk o_sign o_signB rst
X_294_ _294_/Q _296_/CLK _294_/D _287_/Y DVDD DVSS sg13g2_dfrbpq_1
XFILLER_9_77 DVDD DVSS sg13g2_fill_1
X_131_ _178_/A _188_/A DVDD DVSS sg13g2_inv_1
X_200_ _200_/Y _189_/A _206_/B _199_/Y DVDD DVSS sg13g2_o21ai_1
X_277_ _277_/Y _277_/A _294_/Q _277_/C DVDD DVSS sg13g2_nand3_1
XFILLER_6_34 DVDD DVSS sg13g2_fill_1
XFILLER_11_0 DVDD DVSS sg13g2_decap_8
Xoutput7 DATA[14] _273_/Y DVDD DVSS sg13g2_buf_1
Xoutput20 o_sign _295_/Q DVDD DVSS sg13g2_buf_1
X_293_ _293_/Q _296_/CLK _293_/D _286_/Y DVDD DVSS sg13g2_dfrbpq_1
XFILLER_12_77 DVDD DVSS sg13g2_fill_1
X_130_ _169_/A _274_/A DVDD DVSS sg13g2_inv_1
X_276_ _277_/C _290_/Q _276_/B DVDD DVSS sg13g2_nand2b_1
XFILLER_9_23 DVDD DVSS sg13g2_fill_2
X_259_ _260_/C _288_/D _259_/B DVDD DVSS sg13g2_nor2_1
Xoutput8 DATA[15] _274_/Y DVDD DVSS sg13g2_buf_1
Xoutput21 o_signB _133_/Y DVDD DVSS sg13g2_buf_1
Xoutput10 DATA[17] _277_/Y DVDD DVSS sg13g2_buf_1
XFILLER_3_14 DVDD DVSS sg13g2_fill_1
X_292_ _292_/Q _292_/CLK _292_/D _285_/Y DVDD DVSS sg13g2_dfrbpq_1
XFILLER_9_35 DVDD DVSS sg13g2_fill_2
XFILLER_9_46 DVDD DVSS sg13g2_fill_2
X_189_ _189_/Y _189_/A _189_/B _189_/C DVDD DVSS sg13g2_nor3_1
X_275_ _275_/Y _277_/A _270_/Y _269_/A DVDD DVSS sg13g2_o21ai_1
X_258_ _258_/Y _274_/A _258_/B _258_/C DVDD DVSS sg13g2_nor3_1
XFILLER_1_0 DVDD DVSS sg13g2_fill_2
Xhold43 _163_/A _295_/Q DVDD DVSS sg13g2_dlygate4sd3_1
Xoutput9 DATA[16] _275_/Y DVDD DVSS sg13g2_buf_1
Xoutput11 DATA[1] _235_/Y DVDD DVSS sg13g2_buf_1
X_291_ _291_/Q _292_/CLK _291_/D _284_/Y DVDD DVSS sg13g2_dfrbpq_1
X_274_ _274_/Y _274_/A _274_/B DVDD DVSS sg13g2_nand2_1
X_188_ _189_/C _188_/A _206_/B DVDD DVSS sg13g2_and2_1
X_257_ _257_/Y _257_/A _272_/A DVDD DVSS sg13g2_nor2_1
Xoutput12 DATA[2] _253_/Y DVDD DVSS sg13g2_buf_1
X_290_ _290_/Q _292_/CLK _290_/D _283_/Y DVDD DVSS sg13g2_dfrbpq_1
XFILLER_2_114 DVDD DVSS sg13g2_fill_1
X_187_ _206_/B _187_/A _279_/A DVDD DVSS sg13g2_xnor2_1
X_273_ _273_/Y _274_/A _273_/B DVDD DVSS sg13g2_nand2_1
X_256_ _256_/Y _274_/A _273_/B DVDD DVSS sg13g2_nor2_1
X_239_ _239_/Y _239_/A _239_/B _239_/C DVDD DVSS sg13g2_nor3_1
Xclkload0 clkload0/Y _296_/CLK DVDD DVSS sg13g2_inv_1
XFILLER_13_7 DVDD DVSS sg13g2_decap_8
XFILLER_6_49 DVDD DVSS sg13g2_fill_1
XFILLER_7_70 DVDD DVSS sg13g2_fill_2
Xoutput13 DATA[3] _256_/Y DVDD DVSS sg13g2_buf_1
X_272_ _272_/Y _272_/A _272_/B DVDD DVSS sg13g2_nor2_1
X_186_ _239_/C _184_/A _288_/D _178_/A DVDD DVSS sg13g2_a21oi_1
X_255_ _273_/B _255_/A _255_/B DVDD DVSS sg13g2_nand2_1
XFILLER_10_81 DVDD DVSS sg13g2_fill_2
X_169_ _169_/Y _169_/A _179_/A DVDD DVSS sg13g2_nor2_1
X_238_ _238_/X _238_/A _238_/B DVDD DVSS sg13g2_xor2_1
Xoutput14 DATA[4] _258_/Y DVDD DVSS sg13g2_buf_1
X_185_ _189_/B _188_/A _241_/C DVDD DVSS sg13g2_nor2_1
X_271_ _271_/Y _277_/A _270_/Y _269_/A DVDD DVSS sg13g2_a21oi_1
X_254_ _254_/Y _276_/B _255_/B DVDD DVSS sg13g2_nand2_1
X_168_ _272_/B _259_/B _232_/A DVDD DVSS sg13g2_nor2_1
X_237_ _238_/B _239_/C _237_/B DVDD DVSS sg13g2_nor2_1
XFILLER_7_61 DVDD DVSS sg13g2_fill_1
Xoutput15 DATA[5] _260_/Y DVDD DVSS sg13g2_buf_1
XFILLER_8_100 DVDD DVSS sg13g2_fill_1
X_270_ _270_/Y _270_/A _292_/Q DVDD DVSS sg13g2_nor2b_1
X_184_ _241_/C _184_/A _279_/A DVDD DVSS sg13g2_nor2_1
X_253_ _253_/Y _269_/A _245_/Y _252_/Y DVDD DVSS sg13g2_o21ai_1
XFILLER_10_83 DVDD DVSS sg13g2_fill_1
X_167_ _232_/A _213_/A _261_/A DVDD DVSS sg13g2_nand2_1
X_219_ _234_/B _217_/Y _218_/X _172_/Y DVDD DVSS sg13g2_a21oi_1
X_236_ _237_/B _257_/A _279_/A _236_/C DVDD DVSS sg13g2_nor3_1
XFILLER_11_7 DVDD DVSS sg13g2_fill_2
Xoutput16 DATA[6] _262_/Y DVDD DVSS sg13g2_buf_1
Xclkbuf_0_clk clkbuf_0_clk/X clk DVDD DVSS sg13g2_buf_16
XFILLER_12_29 DVDD DVSS sg13g2_fill_1
XFILLER_9_19 DVDD DVSS sg13g2_decap_4
X_166_ _259_/B _239_/A _241_/B DVDD DVSS sg13g2_nand2_1
X_183_ _198_/B _177_/Y _182_/Y _172_/Y DVDD DVSS sg13g2_a21oi_1
X_235_ _235_/Y _169_/A _233_/Y _234_/X DVDD DVSS sg13g2_o21ai_1
Xfanout40 _179_/A _279_/A DVDD DVSS sg13g2_buf_1
X_252_ _252_/Y _247_/Y _252_/B DVDD DVSS sg13g2_nand2b_1
XFILLER_10_95 DVDD DVSS sg13g2_fill_2
X_149_ _149_/Y _162_/A _277_/A DVDD DVSS sg13g2_nand2_1
X_218_ _218_/X _165_/Y _206_/B _238_/A DVDD DVSS sg13g2_a21o_1
Xoutput17 DATA[7] _263_/Y DVDD DVSS sg13g2_buf_1
XFILLER_7_41 DVDD DVSS sg13g2_fill_2
XFILLER_7_52 DVDD DVSS sg13g2_decap_8
XFILLER_7_96 DVDD DVSS sg13g2_fill_2
XFILLER_13_62 DVDD DVSS sg13g2_decap_8
XFILLER_13_73 DVDD DVSS sg13g2_fill_1
XFILLER_4_86 DVDD DVSS sg13g2_fill_2
XFILLER_8_0 DVDD DVSS sg13g2_decap_8
X_182_ _182_/Y _279_/A _236_/C _181_/X DVDD DVSS sg13g2_o21ai_1
Xfanout41 _279_/A _288_/Q DVDD DVSS sg13g2_buf_1
Xfanout30 _213_/A _292_/Q DVDD DVSS sg13g2_buf_1
X_251_ _252_/B _213_/A _181_/X _250_/Y DVDD DVSS sg13g2_a21oi_1
XFILLER_10_63 DVDD DVSS sg13g2_decap_4
XFILLER_10_74 DVDD DVSS sg13g2_fill_2
X_148_ _151_/A _147_/A _147_/B _145_/X DVDD DVSS sg13g2_a21oi_1
X_165_ _165_/Y _188_/A _187_/A DVDD DVSS sg13g2_nand2_1
X_217_ _217_/Y _189_/B _189_/C _238_/A DVDD DVSS sg13g2_o21ai_1
X_234_ _234_/X _274_/A _234_/B _234_/C _234_/D DVDD DVSS sg13g2_or4_1
Xoutput18 DATA[8] _264_/Y DVDD DVSS sg13g2_buf_1
XFILLER_13_30 DVDD DVSS sg13g2_decap_8
XFILLER_13_85 DVDD DVSS sg13g2_decap_4
X_164_ _241_/B _188_/A _187_/A DVDD DVSS sg13g2_and2_1
X_181_ _181_/X _229_/A _270_/A DVDD DVSS sg13g2_and2_1
X_233_ _233_/Y _290_/Q _204_/Y _226_/Y _231_/Y _232_/Y DVDD DVSS sg13g2_a221oi_1
Xfanout42 _286_/A _287_/A DVDD DVSS sg13g2_buf_1
Xfanout31 _257_/A _292_/Q DVDD DVSS sg13g2_buf_1
X_250_ _250_/Y _269_/A _250_/B _250_/C DVDD DVSS sg13g2_nand3_1
X_147_ _292_/D _147_/A _147_/B DVDD DVSS sg13g2_xor2_1
X_216_ _216_/Y _193_/Y _198_/Y _200_/Y _215_/Y DVDD DVSS sg13g2_a22oi_1
Xoutput19 DATA[9] _265_/Y DVDD DVSS sg13g2_buf_1
XFILLER_7_21 DVDD DVSS sg13g2_decap_8
X_180_ _270_/A _179_/A _241_/B _238_/A DVDD DVSS sg13g2_a21oi_1
Xfanout32 _189_/A _248_/B DVDD DVSS sg13g2_buf_1
XFILLER_10_76 DVDD DVSS sg13g2_fill_1
X_163_ _295_/D _163_/A _171_/A DVDD DVSS sg13g2_xnor2_1
X_232_ _232_/Y _232_/A _232_/B DVDD DVSS sg13g2_nor2_1
X_146_ _147_/B _146_/A _257_/A DVDD DVSS sg13g2_xor2_1
X_215_ _215_/Y _204_/Y _205_/Y _214_/Y DVDD DVSS sg13g2_a21oi_1
XFILLER_6_0 DVDD DVSS sg13g2_decap_8
X_162_ _171_/A _162_/A _169_/A _162_/C _255_/A DVDD DVSS sg13g2_nand4_1
X_231_ _231_/Y _199_/A _230_/Y _228_/Y DVDD DVSS sg13g2_o21ai_1
Xfanout33 _238_/A _239_/A DVDD DVSS sg13g2_buf_1
Xfanout22 _258_/B _260_/B DVDD DVSS sg13g2_buf_1
XFILLER_1_68 DVDD DVSS sg13g2_fill_1
X_145_ _145_/X _146_/A _257_/A DVDD DVSS sg13g2_and2_1
X_214_ _214_/Y _274_/A _214_/B _214_/C DVDD DVSS sg13g2_nand3_1
Xinput1 _287_/A rst DVDD DVSS sg13g2_buf_1
XFILLER_7_89 DVDD DVSS sg13g2_fill_2
XFILLER_13_44 DVDD DVSS sg13g2_decap_8
XFILLER_13_55 DVDD DVSS sg13g2_decap_8
Xfanout34 _239_/A _248_/B DVDD DVSS sg13g2_buf_1
Xfanout23 _146_/A _296_/Q DVDD DVSS sg13g2_buf_1
XFILLER_10_34 DVDD DVSS sg13g2_decap_8
XFILLER_10_45 DVDD DVSS sg13g2_decap_4
XFILLER_10_67 DVDD DVSS sg13g2_fill_2
X_161_ _255_/A _189_/A _258_/B DVDD DVSS sg13g2_nor2_1
X_230_ _230_/Y _270_/A _230_/B DVDD DVSS sg13g2_xnor2_1
X_144_ _147_/A _143_/A _143_/B _141_/Y DVDD DVSS sg13g2_o21ai_1
X_213_ _214_/C _213_/A _261_/A _213_/C _232_/B DVDD DVSS sg13g2_nand4_1
XFILLER_12_114 DVDD DVSS sg13g2_fill_1
XFILLER_13_23 DVDD DVSS sg13g2_decap_8
XFILLER_13_78 DVDD DVSS sg13g2_decap_8
XFILLER_13_89 DVDD DVSS sg13g2_fill_1
Xfanout35 _248_/B _291_/Q DVDD DVSS sg13g2_buf_1
Xfanout24 _162_/A _296_/Q DVDD DVSS sg13g2_buf_1
X_143_ _291_/D _143_/A _143_/B DVDD DVSS sg13g2_xor2_1
X_160_ _276_/B _239_/A _213_/A DVDD DVSS sg13g2_nor2_1
X_212_ _232_/B _178_/A _288_/D _211_/A DVDD DVSS sg13g2_o21ai_1
X_289_ _289_/Q _292_/CLK _289_/D _282_/Y DVDD DVSS sg13g2_dfrbpq_1
Xfanout36 _187_/A _184_/A DVDD DVSS sg13g2_buf_1
Xfanout25 _274_/A _294_/Q DVDD DVSS sg13g2_buf_1
X_288_ _288_/Q _292_/CLK _288_/D _281_/Y DVDD DVSS sg13g2_dfrbpq_1
XFILLER_4_0 DVDD DVSS sg13g2_fill_2
XFILLER_7_59 DVDD DVSS sg13g2_fill_2
X_142_ _143_/B _146_/A _189_/A DVDD DVSS sg13g2_xnor2_1
X_211_ _211_/Y _211_/A DVDD DVSS sg13g2_inv_1
XFILLER_13_14 DVDD DVSS sg13g2_decap_4
XFILLER_13_69 DVDD DVSS sg13g2_decap_4
XFILLER_1_104 DVDD DVSS sg13g2_fill_2
XFILLER_5_81 DVDD DVSS sg13g2_fill_2
XFILLER_8_7 DVDD DVSS sg13g2_fill_2
Xfanout37 _184_/A _290_/Q DVDD DVSS sg13g2_buf_1
Xfanout26 _269_/A _272_/A DVDD DVSS sg13g2_buf_1
X_141_ _141_/Y _146_/A _189_/A DVDD DVSS sg13g2_nand2_1
X_210_ _211_/A _239_/A _290_/Q DVDD DVSS sg13g2_nor2_1
X_287_ _287_/Y _287_/A DVDD DVSS sg13g2_inv_1
XFILLER_12_0 DVDD DVSS sg13g2_decap_8
XFILLER_8_81 DVDD DVSS sg13g2_fill_1
Xfanout38 _188_/A _205_/B DVDD DVSS sg13g2_buf_1
Xfanout27 _272_/A _294_/Q DVDD DVSS sg13g2_buf_1
XFILLER_13_37 DVDD DVSS sg13g2_decap_8
XFILLER_1_18 DVDD DVSS sg13g2_fill_2
X_286_ _286_/Y _286_/A DVDD DVSS sg13g2_inv_1
XFILLER_10_27 DVDD DVSS sg13g2_decap_8
XFILLER_10_49 DVDD DVSS sg13g2_fill_1
X_140_ _143_/A _278_/A _278_/B _135_/X DVDD DVSS sg13g2_a21oi_1
X_269_ _269_/Y _269_/A _269_/B DVDD DVSS sg13g2_nor2_1
XFILLER_11_70 DVDD DVSS sg13g2_fill_2
XFILLER_7_28 DVDD DVSS sg13g2_fill_1
Xfanout39 _205_/B _289_/Q DVDD DVSS sg13g2_buf_1
Xfanout28 _261_/A _277_/A DVDD DVSS sg13g2_buf_1
X_285_ _285_/Y _286_/A DVDD DVSS sg13g2_inv_1
XFILLER_2_0 DVDD DVSS sg13g2_fill_2
X_199_ _199_/Y _199_/A _177_/Y DVDD DVSS sg13g2_nor2b_1
X_268_ _269_/B _173_/Y _211_/A _232_/A DVDD DVSS sg13g2_a21oi_1
XFILLER_8_50 DVDD DVSS sg13g2_fill_1
XFILLER_6_7 DVDD DVSS sg13g2_fill_1
Xfanout29 _277_/A _293_/Q DVDD DVSS sg13g2_buf_1
X_284_ _284_/Y _286_/A DVDD DVSS sg13g2_inv_1
XFILLER_2_85 DVDD DVSS sg13g2_fill_2
X_198_ _198_/Y _272_/A _198_/B _198_/C _198_/D DVDD DVSS sg13g2_nor4_1
X_267_ _267_/Y _267_/A _267_/B DVDD DVSS sg13g2_nand2_1
Xclkbuf_1_0__f_clk _292_/CLK clkbuf_0_clk/X DVDD DVSS sg13g2_buf_16
XFILLER_10_0 DVDD DVSS sg13g2_fill_2
X_283_ _283_/Y _286_/A DVDD DVSS sg13g2_inv_1
XFILLER_11_95 DVDD DVSS sg13g2_fill_2
X_197_ _198_/D _259_/B _175_/Y _199_/A DVDD DVSS sg13g2_a21oi_1
X_266_ _267_/B _241_/C _241_/D _257_/Y DVDD DVSS sg13g2_o21ai_1
X_249_ _250_/C _213_/A _211_/A _261_/A DVDD DVSS sg13g2_o21ai_1
X_196_ _199_/A _261_/A _257_/A DVDD DVSS sg13g2_nand2b_1
X_282_ _282_/Y _286_/A DVDD DVSS sg13g2_inv_1
X_265_ _265_/Y _277_/A _254_/Y _269_/A DVDD DVSS sg13g2_a21oi_1
XFILLER_0_0 DVDD DVSS sg13g2_fill_2
XFILLER_11_63 DVDD DVSS sg13g2_decap_8
X_179_ _227_/B _179_/A _241_/B DVDD DVSS sg13g2_nand2_1
X_248_ _250_/B _255_/B _248_/B _258_/B DVDD DVSS sg13g2_nand3b_1
X_281_ _281_/Y _286_/A DVDD DVSS sg13g2_inv_1
XFILLER_11_31 DVDD DVSS sg13g2_fill_1
XFILLER_11_42 DVDD DVSS sg13g2_fill_2
X_195_ _198_/C _239_/A _178_/A _270_/A _227_/C _258_/B DVDD DVSS sg13g2_a221oi_1
X_247_ _247_/Y _213_/C _230_/B _274_/B DVDD DVSS sg13g2_a21oi_1
X_264_ _264_/Y _213_/A _260_/C _267_/A DVDD DVSS sg13g2_a21oi_1
XFILLER_8_65 DVDD DVSS sg13g2_fill_2
X_178_ _236_/C _178_/A _187_/A DVDD DVSS sg13g2_nand2_1
XFILLER_5_22 DVDD DVSS sg13g2_decap_4
XFILLER_2_23 DVDD DVSS sg13g2_fill_2
X_194_ _227_/C _173_/Y _194_/B DVDD DVSS sg13g2_nand2b_1
X_280_ _280_/Y _286_/A DVDD DVSS sg13g2_inv_1
X_263_ _263_/Y _213_/A _258_/C _267_/A DVDD DVSS sg13g2_a21oi_1
XFILLER_11_21 DVDD DVSS sg13g2_fill_1
XFILLER_11_76 DVDD DVSS sg13g2_fill_2
X_177_ _177_/Y _176_/Y _238_/A DVDD DVSS sg13g2_nand2b_1
X_246_ _274_/B _258_/B _259_/B DVDD DVSS sg13g2_nand2b_1
XFILLER_12_7 DVDD DVSS sg13g2_fill_2
X_229_ _230_/B _229_/A _255_/B DVDD DVSS sg13g2_nand2_1
XFILLER_11_44 DVDD DVSS sg13g2_fill_1
X_193_ _193_/Y _189_/Y _193_/B DVDD DVSS sg13g2_nand2b_1
X_262_ _262_/Y _213_/A _211_/Y _267_/A DVDD DVSS sg13g2_a21oi_1
X_159_ _260_/B _292_/Q _277_/A DVDD DVSS sg13g2_or2_1
X_176_ _176_/Y _179_/A _201_/A _175_/A _184_/A DVDD DVSS sg13g2_a22oi_1
X_228_ _228_/Y _258_/B _228_/B DVDD DVSS sg13g2_nand2b_1
X_245_ _245_/Y _261_/A _238_/X _244_/Y DVDD DVSS sg13g2_o21ai_1
X_192_ _193_/B _189_/A _191_/Y _232_/A DVDD DVSS sg13g2_a21oi_1
X_261_ _267_/A _261_/A _269_/A DVDD DVSS sg13g2_or2_1
XFILLER_9_0 DVDD DVSS sg13g2_decap_8
X_175_ _175_/Y _175_/A DVDD DVSS sg13g2_inv_1
X_244_ _244_/Y _239_/Y _240_/Y _243_/Y DVDD DVSS sg13g2_o21ai_1
X_158_ _162_/C _288_/D _229_/A DVDD DVSS sg13g2_nor2_1
X_227_ _228_/B _239_/A _227_/B _227_/C DVDD DVSS sg13g2_nand3_1
XFILLER_5_69 DVDD DVSS sg13g2_fill_2
Xclkbuf_1_1__f_clk _296_/CLK clkbuf_0_clk/X DVDD DVSS sg13g2_buf_16
XFILLER_6_90 DVDD DVSS sg13g2_fill_1
X_191_ _191_/Y _288_/D _201_/A DVDD DVSS sg13g2_xnor2_1
X_260_ _260_/Y _269_/A _260_/B _260_/C DVDD DVSS sg13g2_nor3_1
X_157_ _229_/A _201_/A DVDD DVSS sg13g2_inv_1
X_174_ _175_/A _205_/B _179_/A DVDD DVSS sg13g2_xnor2_1
X_226_ _226_/Y _201_/A _175_/A _276_/B DVDD DVSS sg13g2_o21ai_1
X_243_ _243_/Y _276_/B _230_/B _242_/Y DVDD DVSS sg13g2_a21oi_1
XFILLER_3_101 DVDD DVSS sg13g2_fill_2
XFILLER_5_26 DVDD DVSS sg13g2_fill_1
X_209_ _213_/C _179_/A _229_/A _239_/A DVDD DVSS sg13g2_o21ai_1
XFILLER_11_14 DVDD DVSS sg13g2_fill_1
XFILLER_11_36 DVDD DVSS sg13g2_fill_1
X_173_ _173_/Y _205_/B _179_/A DVDD DVSS sg13g2_nor2_1
X_190_ _194_/B _205_/B _184_/A _279_/A DVDD DVSS sg13g2_o21ai_1
X_242_ _242_/Y _241_/Y _261_/A DVDD DVSS sg13g2_nand2b_1
X_156_ _201_/A _205_/B _184_/A DVDD DVSS sg13g2_nor2_1
X_225_ _234_/D _189_/C _224_/Y _223_/Y DVDD DVSS sg13g2_o21ai_1
X_139_ _278_/B _146_/A _187_/A DVDD DVSS sg13g2_xor2_1
X_208_ _214_/B _248_/B _191_/Y _207_/Y DVDD DVSS sg13g2_o21ai_1
XFILLER_7_0 DVDD DVSS sg13g2_decap_4
X_155_ _239_/B _187_/A _288_/D DVDD DVSS sg13g2_nor2_1
X_172_ _172_/Y _257_/A _261_/A DVDD DVSS sg13g2_nand2b_1
X_224_ _224_/Y _199_/A _236_/C DVDD DVSS sg13g2_nand2b_1
X_241_ _241_/Y _257_/A _241_/B _241_/C _241_/D DVDD DVSS sg13g2_nor4_1
X_138_ _278_/A _288_/D _279_/B _136_/Y DVDD DVSS sg13g2_o21ai_1
X_207_ _207_/Y _248_/B _206_/B _258_/B DVDD DVSS sg13g2_a21oi_1
XFILLER_11_27 DVDD DVSS sg13g2_decap_4
X_171_ _296_/D _171_/A _171_/B DVDD DVSS sg13g2_and2_1
X_240_ _240_/Y _241_/B _241_/D _257_/A DVDD DVSS sg13g2_o21ai_1
X_154_ _294_/D _154_/A _154_/B DVDD DVSS sg13g2_xnor2_1
X_223_ _223_/Y _187_/A _205_/Y _206_/Y DVDD DVSS sg13g2_o21ai_1
XFILLER_5_18 DVDD DVSS sg13g2_fill_1
X_137_ _279_/B _146_/A _188_/A DVDD DVSS sg13g2_xnor2_1
X_206_ _206_/Y _258_/B _206_/B DVDD DVSS sg13g2_nor2_1
XFILLER_3_95 DVDD DVSS sg13g2_fill_2
X_170_ _171_/B _272_/B _169_/Y _162_/A DVDD DVSS sg13g2_a21o_1
XFILLER_0_74 DVDD DVSS sg13g2_fill_2
XFILLER_12_82 DVDD DVSS sg13g2_decap_4
XFILLER_8_18 DVDD DVSS sg13g2_fill_1
XFILLER_8_29 DVDD DVSS sg13g2_fill_1
X_136_ _136_/Y _146_/A _188_/A DVDD DVSS sg13g2_nand2_1
X_153_ _154_/B _162_/A _274_/A DVDD DVSS sg13g2_xnor2_1
X_205_ _205_/Y _189_/A _205_/B DVDD DVSS sg13g2_nand2b_1
X_222_ _234_/C _232_/A _222_/B DVDD DVSS sg13g2_nor2_1
Xoutput2 DATA[0] _216_/Y DVDD DVSS sg13g2_buf_1
XFILLER_5_0 DVDD DVSS sg13g2_fill_1
X_152_ _154_/A _151_/A _151_/B _149_/Y DVDD DVSS sg13g2_o21ai_1
X_221_ _222_/B _238_/A _176_/Y _220_/Y DVDD DVSS sg13g2_o21ai_1
XFILLER_9_62 DVDD DVSS sg13g2_decap_8
XFILLER_9_73 DVDD DVSS sg13g2_decap_4
X_135_ _135_/X _146_/A _187_/A DVDD DVSS sg13g2_and2_1
X_204_ _204_/Y _258_/C _255_/B _172_/Y DVDD DVSS sg13g2_a21oi_1
XFILLER_6_30 DVDD DVSS sg13g2_decap_4
XFILLER_11_19 DVDD DVSS sg13g2_fill_2
XFILLER_7_4 DVDD DVSS sg13g2_fill_1
XFILLER_9_101 DVDD DVSS sg13g2_fill_1
Xoutput3 DATA[10] _267_/Y DVDD DVSS sg13g2_buf_1
XFILLER_12_40 DVDD DVSS sg13g2_fill_2
X_134_ _134_/Y _286_/A DVDD DVSS sg13g2_inv_1
X_151_ _293_/D _151_/A _151_/B DVDD DVSS sg13g2_xor2_1
X_203_ _255_/B _205_/B _179_/A _184_/A DVDD DVSS sg13g2_o21ai_1
X_220_ _220_/Y _188_/A _241_/C _238_/A DVDD DVSS sg13g2_o21ai_1
XFILLER_9_85 DVDD DVSS sg13g2_fill_1
XFILLER_13_0 DVDD DVSS sg13g2_decap_8
Xoutput4 DATA[11] _269_/Y DVDD DVSS sg13g2_buf_1
X_150_ _151_/B _162_/A _277_/A DVDD DVSS sg13g2_xnor2_1
X_296_ _296_/Q _296_/CLK _296_/D _280_/Y DVDD DVSS sg13g2_dfrbpq_1
X_279_ _289_/D _279_/A _279_/B DVDD DVSS sg13g2_xnor2_1
X_133_ _133_/Y _295_/Q DVDD DVSS sg13g2_inv_1
X_202_ _241_/D _205_/B _184_/A _238_/A DVDD DVSS sg13g2_o21ai_1
XFILLER_6_21 DVDD DVSS sg13g2_decap_4
XFILLER_6_65 DVDD DVSS sg13g2_fill_2
XFILLER_3_55 DVDD DVSS sg13g2_fill_2
Xoutput5 DATA[12] _271_/Y DVDD DVSS sg13g2_buf_1
X_295_ _295_/Q _296_/CLK _295_/D _134_/Y DVDD DVSS sg13g2_dfrbpq_1
XFILLER_10_102 DVDD DVSS sg13g2_fill_1
XFILLER_12_42 DVDD DVSS sg13g2_fill_1
XFILLER_12_75 DVDD DVSS sg13g2_fill_2
XFILLER_12_86 DVDD DVSS sg13g2_fill_2
XFILLER_3_0 DVDD DVSS sg13g2_fill_2
X_132_ _288_/D _279_/A DVDD DVSS sg13g2_inv_1
X_201_ _258_/C _201_/A _189_/A DVDD DVSS sg13g2_nor2b_1
X_278_ _290_/D _278_/A _278_/B DVDD DVSS sg13g2_xor2_1
XFILLER_6_77 DVDD DVSS sg13g2_fill_1
Xoutput6 DATA[13] _272_/Y DVDD DVSS sg13g2_buf_1
.ends
