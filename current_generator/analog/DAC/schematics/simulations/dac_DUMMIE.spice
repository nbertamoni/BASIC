** sch_path: /home/designer/shared/BASIC/current_generator/analog/DAC/schematics/dac_DUMMIE.sch
.subckt dac_DUMMIE AVDD AVSS
*.PININFO AVDD:B AVSS:B
MMN0 AVSS AVDD AVSS AVSS sg13_lv_nmos w=740.00n l=130.00n ng=1
MMP0 AVSS AVDD AVDD AVDD sg13_lv_pmos w=1.12u l=130.00n ng=1
MMP11 AVDD AVDD AVDD AVDD sg13_lv_pmos w=0.72u l=1.5u ng=1
MP12 AVDD AVDD AVDD AVDD sg13_lv_pmos w=0.72u l=1.5u ng=1
MP13 AVDD AVDD AVDD AVDD sg13_lv_pmos w=0.72u l=1.5u ng=1
MP14 AVDD AVDD AVDD AVDD sg13_lv_pmos w=0.72u l=1.5u ng=1
MP15 AVDD AVDD AVDD AVDD sg13_lv_pmos w=0.72u l=1.5u ng=1
MP16 AVDD AVDD AVDD AVDD sg13_lv_pmos w=0.72u l=1.5u ng=1
MP17 AVDD AVDD AVDD AVDD sg13_lv_pmos w=0.72u l=1.5u ng=1
MP18 AVDD AVDD AVDD AVDD sg13_lv_pmos w=0.72u l=1.5u ng=1
MMP51 AVDD AVDD AVDD AVDD sg13_lv_pmos w=0.72u l=3u ng=1
MP52 AVDD AVDD AVDD AVDD sg13_lv_pmos w=0.72u l=3u ng=1
MP53 AVDD AVDD AVDD AVDD sg13_lv_pmos w=0.72u l=3u ng=1
MP54 AVDD AVDD AVDD AVDD sg13_lv_pmos w=0.72u l=3u ng=1
MMP21 AVDD AVDD AVDD AVDD sg13_lv_pmos w=0.72u l=3u ng=1
MP22 AVDD AVDD AVDD AVDD sg13_lv_pmos w=0.72u l=3u ng=1
MP23 AVDD AVDD AVDD AVDD sg13_lv_pmos w=0.72u l=3u ng=1
MP24 AVDD AVDD AVDD AVDD sg13_lv_pmos w=0.72u l=3u ng=1
.ends
