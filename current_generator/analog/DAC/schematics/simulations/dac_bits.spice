** sch_path: /home/designer/shared/BASIC/current_generator/analog/DAC/schematics/dac_bits.sch
.subckt dac_bits AVDD AVSS en_bb DATA[17] DATA[16] DATA[15] DATA[14] DATA[13] DATA[12] DATA[11] DATA[10] DATA[9] DATA[8] DATA[7]
+ DATA[6] DATA[5] DATA[4] DATA[3] DATA[2] DATA[1] DATA[0] VBIAS ISUM
*.PININFO AVDD:B AVSS:B en_bb:B DATA[17:0]:B VBIAS:B ISUM:B
xb0 AVDD AVSS VBIAS en_bb DATA[0] ISUM dac_gold
xb1[1] AVDD AVSS VBIAS en_bb DATA[1] ISUM dac_gold
xb1[0] AVDD AVSS VBIAS en_bb DATA[1] ISUM dac_gold
xb2[3] AVDD AVSS VBIAS en_bb DATA[2] ISUM dac_gold
xb2[2] AVDD AVSS VBIAS en_bb DATA[2] ISUM dac_gold
xb2[1] AVDD AVSS VBIAS en_bb DATA[2] ISUM dac_gold
xb2[0] AVDD AVSS VBIAS en_bb DATA[2] ISUM dac_gold
xb3[7] AVDD AVSS VBIAS en_bb DATA[3] ISUM dac_gold
xb3[6] AVDD AVSS VBIAS en_bb DATA[3] ISUM dac_gold
xb3[5] AVDD AVSS VBIAS en_bb DATA[3] ISUM dac_gold
xb3[4] AVDD AVSS VBIAS en_bb DATA[3] ISUM dac_gold
xb3[3] AVDD AVSS VBIAS en_bb DATA[3] ISUM dac_gold
xb3[2] AVDD AVSS VBIAS en_bb DATA[3] ISUM dac_gold
xb3[1] AVDD AVSS VBIAS en_bb DATA[3] ISUM dac_gold
xb3[0] AVDD AVSS VBIAS en_bb DATA[3] ISUM dac_gold
xb4[7] AVDD AVSS VBIAS en_bb DATA[4] ISUM dac_gold
xb4[6] AVDD AVSS VBIAS en_bb DATA[4] ISUM dac_gold
xb4[5] AVDD AVSS VBIAS en_bb DATA[4] ISUM dac_gold
xb4[4] AVDD AVSS VBIAS en_bb DATA[4] ISUM dac_gold
xb4[3] AVDD AVSS VBIAS en_bb DATA[4] ISUM dac_gold
xb4[2] AVDD AVSS VBIAS en_bb DATA[4] ISUM dac_gold
xb4[1] AVDD AVSS VBIAS en_bb DATA[4] ISUM dac_gold
xb4[0] AVDD AVSS VBIAS en_bb DATA[4] ISUM dac_gold
xb5[7] AVDD AVSS VBIAS en_bb DATA[5] ISUM dac_gold
xb5[6] AVDD AVSS VBIAS en_bb DATA[5] ISUM dac_gold
xb5[5] AVDD AVSS VBIAS en_bb DATA[5] ISUM dac_gold
xb5[4] AVDD AVSS VBIAS en_bb DATA[5] ISUM dac_gold
xb5[3] AVDD AVSS VBIAS en_bb DATA[5] ISUM dac_gold
xb5[2] AVDD AVSS VBIAS en_bb DATA[5] ISUM dac_gold
xb5[1] AVDD AVSS VBIAS en_bb DATA[5] ISUM dac_gold
xb5[0] AVDD AVSS VBIAS en_bb DATA[5] ISUM dac_gold
xb6[7] AVDD AVSS VBIAS en_bb DATA[6] ISUM dac_gold
xb6[6] AVDD AVSS VBIAS en_bb DATA[6] ISUM dac_gold
xb6[5] AVDD AVSS VBIAS en_bb DATA[6] ISUM dac_gold
xb6[4] AVDD AVSS VBIAS en_bb DATA[6] ISUM dac_gold
xb6[3] AVDD AVSS VBIAS en_bb DATA[6] ISUM dac_gold
xb6[2] AVDD AVSS VBIAS en_bb DATA[6] ISUM dac_gold
xb6[1] AVDD AVSS VBIAS en_bb DATA[6] ISUM dac_gold
xb6[0] AVDD AVSS VBIAS en_bb DATA[6] ISUM dac_gold
xb7[7] AVDD AVSS VBIAS en_bb DATA[7] ISUM dac_gold
xb7[6] AVDD AVSS VBIAS en_bb DATA[7] ISUM dac_gold
xb7[5] AVDD AVSS VBIAS en_bb DATA[7] ISUM dac_gold
xb7[4] AVDD AVSS VBIAS en_bb DATA[7] ISUM dac_gold
xb7[3] AVDD AVSS VBIAS en_bb DATA[7] ISUM dac_gold
xb7[2] AVDD AVSS VBIAS en_bb DATA[7] ISUM dac_gold
xb7[1] AVDD AVSS VBIAS en_bb DATA[7] ISUM dac_gold
xb7[0] AVDD AVSS VBIAS en_bb DATA[7] ISUM dac_gold
xb8[7] AVDD AVSS VBIAS en_bb DATA[8] ISUM dac_gold
xb8[6] AVDD AVSS VBIAS en_bb DATA[8] ISUM dac_gold
xb8[5] AVDD AVSS VBIAS en_bb DATA[8] ISUM dac_gold
xb8[4] AVDD AVSS VBIAS en_bb DATA[8] ISUM dac_gold
xb8[3] AVDD AVSS VBIAS en_bb DATA[8] ISUM dac_gold
xb8[2] AVDD AVSS VBIAS en_bb DATA[8] ISUM dac_gold
xb8[1] AVDD AVSS VBIAS en_bb DATA[8] ISUM dac_gold
xb8[0] AVDD AVSS VBIAS en_bb DATA[8] ISUM dac_gold
xb9[7] AVDD AVSS VBIAS en_bb DATA[9] ISUM dac_gold
xb9[6] AVDD AVSS VBIAS en_bb DATA[9] ISUM dac_gold
xb9[5] AVDD AVSS VBIAS en_bb DATA[9] ISUM dac_gold
xb9[4] AVDD AVSS VBIAS en_bb DATA[9] ISUM dac_gold
xb9[3] AVDD AVSS VBIAS en_bb DATA[9] ISUM dac_gold
xb9[2] AVDD AVSS VBIAS en_bb DATA[9] ISUM dac_gold
xb9[1] AVDD AVSS VBIAS en_bb DATA[9] ISUM dac_gold
xb9[0] AVDD AVSS VBIAS en_bb DATA[9] ISUM dac_gold
xb10[7] AVDD AVSS VBIAS en_bb DATA[10] ISUM dac_gold
xb10[6] AVDD AVSS VBIAS en_bb DATA[10] ISUM dac_gold
xb10[5] AVDD AVSS VBIAS en_bb DATA[10] ISUM dac_gold
xb10[4] AVDD AVSS VBIAS en_bb DATA[10] ISUM dac_gold
xb10[3] AVDD AVSS VBIAS en_bb DATA[10] ISUM dac_gold
xb10[2] AVDD AVSS VBIAS en_bb DATA[10] ISUM dac_gold
xb10[1] AVDD AVSS VBIAS en_bb DATA[10] ISUM dac_gold
xb10[0] AVDD AVSS VBIAS en_bb DATA[10] ISUM dac_gold
xb11[7] AVDD AVSS VBIAS en_bb DATA[11] ISUM dac_gold
xb11[6] AVDD AVSS VBIAS en_bb DATA[11] ISUM dac_gold
xb11[5] AVDD AVSS VBIAS en_bb DATA[11] ISUM dac_gold
xb11[4] AVDD AVSS VBIAS en_bb DATA[11] ISUM dac_gold
xb11[3] AVDD AVSS VBIAS en_bb DATA[11] ISUM dac_gold
xb11[2] AVDD AVSS VBIAS en_bb DATA[11] ISUM dac_gold
xb11[1] AVDD AVSS VBIAS en_bb DATA[11] ISUM dac_gold
xb11[0] AVDD AVSS VBIAS en_bb DATA[11] ISUM dac_gold
xb12[7] AVDD AVSS VBIAS en_bb DATA[12] ISUM dac_gold
xb12[6] AVDD AVSS VBIAS en_bb DATA[12] ISUM dac_gold
xb12[5] AVDD AVSS VBIAS en_bb DATA[12] ISUM dac_gold
xb12[4] AVDD AVSS VBIAS en_bb DATA[12] ISUM dac_gold
xb12[3] AVDD AVSS VBIAS en_bb DATA[12] ISUM dac_gold
xb12[2] AVDD AVSS VBIAS en_bb DATA[12] ISUM dac_gold
xb12[1] AVDD AVSS VBIAS en_bb DATA[12] ISUM dac_gold
xb12[0] AVDD AVSS VBIAS en_bb DATA[12] ISUM dac_gold
xb13[7] AVDD AVSS VBIAS en_bb DATA[13] ISUM dac_gold
xb13[6] AVDD AVSS VBIAS en_bb DATA[13] ISUM dac_gold
xb13[5] AVDD AVSS VBIAS en_bb DATA[13] ISUM dac_gold
xb13[4] AVDD AVSS VBIAS en_bb DATA[13] ISUM dac_gold
xb13[3] AVDD AVSS VBIAS en_bb DATA[13] ISUM dac_gold
xb13[2] AVDD AVSS VBIAS en_bb DATA[13] ISUM dac_gold
xb13[1] AVDD AVSS VBIAS en_bb DATA[13] ISUM dac_gold
xb13[0] AVDD AVSS VBIAS en_bb DATA[13] ISUM dac_gold
xb14[7] AVDD AVSS VBIAS en_bb DATA[14] ISUM dac_gold
xb14[6] AVDD AVSS VBIAS en_bb DATA[14] ISUM dac_gold
xb14[5] AVDD AVSS VBIAS en_bb DATA[14] ISUM dac_gold
xb14[4] AVDD AVSS VBIAS en_bb DATA[14] ISUM dac_gold
xb14[3] AVDD AVSS VBIAS en_bb DATA[14] ISUM dac_gold
xb14[2] AVDD AVSS VBIAS en_bb DATA[14] ISUM dac_gold
xb14[1] AVDD AVSS VBIAS en_bb DATA[14] ISUM dac_gold
xb14[0] AVDD AVSS VBIAS en_bb DATA[14] ISUM dac_gold
xb15[7] AVDD AVSS VBIAS en_bb DATA[15] ISUM dac_gold
xb15[6] AVDD AVSS VBIAS en_bb DATA[15] ISUM dac_gold
xb15[5] AVDD AVSS VBIAS en_bb DATA[15] ISUM dac_gold
xb15[4] AVDD AVSS VBIAS en_bb DATA[15] ISUM dac_gold
xb15[3] AVDD AVSS VBIAS en_bb DATA[15] ISUM dac_gold
xb15[2] AVDD AVSS VBIAS en_bb DATA[15] ISUM dac_gold
xb15[1] AVDD AVSS VBIAS en_bb DATA[15] ISUM dac_gold
xb15[0] AVDD AVSS VBIAS en_bb DATA[15] ISUM dac_gold
xb16[7] AVDD AVSS VBIAS en_bb DATA[16] ISUM dac_gold
xb16[6] AVDD AVSS VBIAS en_bb DATA[16] ISUM dac_gold
xb16[5] AVDD AVSS VBIAS en_bb DATA[16] ISUM dac_gold
xb16[4] AVDD AVSS VBIAS en_bb DATA[16] ISUM dac_gold
xb16[3] AVDD AVSS VBIAS en_bb DATA[16] ISUM dac_gold
xb16[2] AVDD AVSS VBIAS en_bb DATA[16] ISUM dac_gold
xb16[1] AVDD AVSS VBIAS en_bb DATA[16] ISUM dac_gold
xb16[0] AVDD AVSS VBIAS en_bb DATA[16] ISUM dac_gold
xb17[7] AVDD AVSS VBIAS en_bb DATA[17] ISUM dac_gold
xb17[6] AVDD AVSS VBIAS en_bb DATA[17] ISUM dac_gold
xb17[5] AVDD AVSS VBIAS en_bb DATA[17] ISUM dac_gold
xb17[4] AVDD AVSS VBIAS en_bb DATA[17] ISUM dac_gold
xb17[3] AVDD AVSS VBIAS en_bb DATA[17] ISUM dac_gold
xb17[2] AVDD AVSS VBIAS en_bb DATA[17] ISUM dac_gold
xb17[1] AVDD AVSS VBIAS en_bb DATA[17] ISUM dac_gold
xb17[0] AVDD AVSS VBIAS en_bb DATA[17] ISUM dac_gold
x1[7] AVDD AVSS VBIAS en_bb AVSS VBIAS dac_gold
x1[6] AVDD AVSS VBIAS en_bb AVSS VBIAS dac_gold
x1[5] AVDD AVSS VBIAS en_bb AVSS VBIAS dac_gold
x1[4] AVDD AVSS VBIAS en_bb AVSS VBIAS dac_gold
x1[3] AVDD AVSS VBIAS en_bb AVSS VBIAS dac_gold
x1[2] AVDD AVSS VBIAS en_bb AVSS VBIAS dac_gold
x1[1] AVDD AVSS VBIAS en_bb AVSS VBIAS dac_gold
x1[0] AVDD AVSS VBIAS en_bb AVSS VBIAS dac_gold
x11 AVDD AVSS dac_DUMMIE
x12 AVDD AVSS dac_DUMMIE
x13 AVDD AVSS dac_DUMMIE
x14 AVDD AVSS dac_DUMMIE
x15 AVDD AVSS dac_DUMMIE
x16 AVDD AVSS dac_DUMMIE
x17 AVDD AVSS dac_DUMMIE
x18 AVDD AVSS dac_DUMMIE
x19 AVDD AVSS dac_DUMMIE
x110 AVDD AVSS dac_DUMMIE
x111 AVDD AVSS dac_DUMMIE
x112 AVDD AVSS dac_DUMMIE
x113 AVDD AVSS dac_DUMMIE
x114 AVDD AVSS dac_DUMMIE
x115 AVDD AVSS dac_DUMMIE
x116 AVDD AVSS dac_DUMMIE
x117 AVDD AVSS dac_DUMMIE
x118 AVDD AVSS dac_DUMMIE
x119 AVDD AVSS dac_DUMMIE
x120 AVDD AVSS dac_DUMMIE
x121 AVDD AVSS dac_DUMMIE
x122 AVDD AVSS dac_DUMMIE
x123 AVDD AVSS dac_DUMMIE
x124 AVDD AVSS dac_DUMMIE
x125 AVDD AVSS dac_DUMMIE
x126 AVDD AVSS dac_DUMMIE
x127 AVDD AVSS dac_DUMMIE
x128 AVDD AVSS dac_DUMMIE
x129 AVDD AVSS dac_DUMMIE
x130 AVDD AVSS dac_DUMMIE
x131 AVDD AVSS dac_DUMMIE
x132 AVDD AVSS dac_DUMMIE
x133 AVDD AVSS dac_DUMMIE
x134 AVDD AVSS dac_DUMMIE
x135 AVDD AVSS dac_DUMMIE
x136 AVDD AVSS dac_DUMMIE
x137 AVDD AVSS dac_DUMMIE
x138 AVDD AVSS dac_DUMMIE
x139 AVDD AVSS dac_DUMMIE
x140 AVDD AVSS dac_DUMMIE
x141 AVDD AVSS dac_DUMMIE
x142 AVDD AVSS dac_DUMMIE
x143 AVDD AVSS dac_DUMMIE
x144 AVDD AVSS dac_DUMMIE
x145 AVDD AVSS dac_DUMMIE
x146 AVDD AVSS dac_DUMMIE
x147 AVDD AVSS dac_DUMMIE
x148 AVDD AVSS dac_DUMMIE
x149 AVDD AVSS dac_DUMMIE
x150 AVDD AVSS dac_DUMMIE
x151 AVDD AVSS dac_DUMMIE
x152 AVDD AVSS dac_DUMMIE
x153 AVDD AVSS dac_DUMMIE
x154 AVDD AVSS dac_DUMMIE
x155 AVDD AVSS dac_DUMMIE
x156 AVDD AVSS dac_DUMMIE
x157 AVDD AVSS dac_DUMMIE
.ends

* expanding   symbol:  dac_gold.sym # of pins=6
** sym_path: /home/designer/shared/BASIC/current_generator/analog/DAC/schematics/dac_gold.sym
** sch_path: /home/designer/shared/BASIC/current_generator/analog/DAC/schematics/dac_gold.sch
.subckt dac_gold AVDD AVSS VBIAS enb DATA ISUM
*.PININFO AVDD:B AVSS:B VBIAS:B enb:B DATA:B ISUM:B
MM1 ISUM VBIAS VS_cm AVDD sg13_lv_pmos w=0.72u l=3u ng=1 m=4
MM2 VBIAS enb AVDD AVDD sg13_lv_pmos w=0.72u l=3u ng=1 m=4
MM3 AVDD AVDD AVDD AVDD sg13_lv_pmos w=0.72u l=1.5u ng=1 m=8
x20 DATA VS_cm AVDD AVSS inverter
.ends

* expanding   symbol:  dac_DUMMIE.sym # of pins=2
** sym_path: /home/designer/shared/BASIC/current_generator/analog/DAC/schematics/dac_DUMMIE.sym
** sch_path: /home/designer/shared/BASIC/current_generator/analog/DAC/schematics/dac_DUMMIE.sch
.subckt dac_DUMMIE AVDD AVSS
*.PININFO AVDD:B AVSS:B
MMN0 AVSS AVDD AVSS AVSS sg13_lv_nmos w=740.00n l=130.00n ng=1
MMP0 AVSS AVDD AVDD AVDD sg13_lv_pmos w=1.12u l=130.00n ng=1
MMP11 AVDD AVDD AVDD AVDD sg13_lv_pmos w=0.72u l=1.5u ng=1
MP12 AVDD AVDD AVDD AVDD sg13_lv_pmos w=0.72u l=1.5u ng=1
MP13 AVDD AVDD AVDD AVDD sg13_lv_pmos w=0.72u l=1.5u ng=1
MP14 AVDD AVDD AVDD AVDD sg13_lv_pmos w=0.72u l=1.5u ng=1
MP15 AVDD AVDD AVDD AVDD sg13_lv_pmos w=0.72u l=1.5u ng=1
MP16 AVDD AVDD AVDD AVDD sg13_lv_pmos w=0.72u l=1.5u ng=1
MP17 AVDD AVDD AVDD AVDD sg13_lv_pmos w=0.72u l=1.5u ng=1
MP18 AVDD AVDD AVDD AVDD sg13_lv_pmos w=0.72u l=1.5u ng=1
MMP51 AVDD AVDD AVDD AVDD sg13_lv_pmos w=0.72u l=3u ng=1
MP52 AVDD AVDD AVDD AVDD sg13_lv_pmos w=0.72u l=3u ng=1
MP53 AVDD AVDD AVDD AVDD sg13_lv_pmos w=0.72u l=3u ng=1
MP54 AVDD AVDD AVDD AVDD sg13_lv_pmos w=0.72u l=3u ng=1
MMP21 AVDD AVDD AVDD AVDD sg13_lv_pmos w=0.72u l=3u ng=1
MP22 AVDD AVDD AVDD AVDD sg13_lv_pmos w=0.72u l=3u ng=1
MP23 AVDD AVDD AVDD AVDD sg13_lv_pmos w=0.72u l=3u ng=1
MP24 AVDD AVDD AVDD AVDD sg13_lv_pmos w=0.72u l=3u ng=1
.ends

* expanding   symbol:  inverter.sym # of pins=4
** sym_path: /home/designer/shared/BASIC/current_generator/analog/DAC/schematics/inverter.sym
** sch_path: /home/designer/shared/BASIC/current_generator/analog/DAC/schematics/inverter.sch
.subckt inverter A Y VDD VSS
*.PININFO Y:O A:I VDD:B VSS:B
MMN0 Y A VSS VSS sg13_lv_nmos w=740.00n l=130.00n ng=1
MMP0 Y A VDD VDD sg13_lv_pmos w=1.12u l=130.00n ng=1
.ends
