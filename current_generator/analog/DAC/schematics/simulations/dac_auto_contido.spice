* ======================================================
* DAC - AUTO CONTIDO
* ======================================================

* ---------- INVERSOR INCORPORADO ---------------------
.subckt sg13g2_inv_1 Y A VDD VSS
*.PININFO Y:O A:I VDD:B VSS:B
MN0 Y A VSS VSS sg13_lv_nmos w=740n l=130n ng=1 m=1
MP0 Y A VDD VDD sg13_lv_pmos w=1.12u l=130n ng=1 m=1
.ends sg13g2_inv_1

* ---------------- DAC -------------------------------
.subckt dac_auto_contido AVDD AVSS VBIAS enb DATA ISUM
*.PININFO AVDD:B AVSS:B VBIAS:B enb:B DATA:B ISUM:B

M1 ISUM VBIAS VS_cm AVDD sg13_lv_pmos w=0.72u l=3u ng=1 m=4
M2 VBIAS enb AVDD AVDD sg13_lv_pmos w=0.360u l=2u ng=1 m=4
M3 AVDD AVDD AVDD AVDD sg13_lv_pmos w=0.360u l=2u ng=1 m=4

x2 VS_cm DATA AVDD AVSS sg13g2_inv_1

.ends dac
