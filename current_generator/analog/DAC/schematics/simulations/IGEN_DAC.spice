** sch_path: /home/designer/shared/current_generator/analog/DAC/IGEN_DAC.sch
.subckt IGEN_DAC

x3 AVDD AVSS VBIAS en_bb AVSS VBIAS dac_thermo
x8 AVDD AVSS en_bb en_b SEL net5 net7 current_mirror
I0 net3 AVSS 200n
V1 AVDD AVSS 1.6
V2 net6 GND 0
V3 SEL AVSS 0
x1 en_b en AVDD AVSS sg13g2_inv_1
x2 en_bb en_b AVDD AVSS sg13g2_inv_1
V6 in AVSS 1.6
x10 inb in AVDD AVSS sg13g2_inv_1
XM1 net1 net1 AVDD AVDD sg13_lv_pmos w=2u l=2u ng=1 m=2
XM2 net2 net1 AVDD AVDD sg13_lv_pmos w=2u l=2u ng=1 m=2
XM3 IBIAS net3 net1 AVDD sg13_lv_pmos w=2u l=2u ng=1 m=2
XM4 net3 net3 net2 AVDD sg13_lv_pmos w=2u l=2u ng=1 m=21
V16 ISUM net4 0
N1 vin_sin AVSS out0 out10 out11 out1 out2 out12 out3 out13 out4 out14 out5 out15 out6 out16 out17 out7 out8 out9 adc_segmentation
x6 AVDD AVSS in inb a b sign sign_b non_overlap
V7 a AVSS 0
V13 b AVSS 1.6
V17 vin_sin AVSS PULSE(0 1.6 200u 2.56u 2.56u 1n 205.121u)
x4 AVDD AVSS VBIAS en_bb out0 out1 out2 net11 byn_dac
V12 ISUM net11 0
V4 en AVSS PULSE(0 1.6 100u 1n 1n 1 2)
R7 net6 AVSS 0.1 m=1
V5 net7 VBIAS 0
V8 IBIAS net5 0
x7 sign sign_b net8 AVSS vop vom dsw
V9 vop net10 0
V15 net9 vom 0
V18 ISUM net8 0
R1 net10 net9 1k m=1
C1 AVDD VBIAS 40p m=1
x5 out8 AVDD out13 out3 out9 out4 out14 AVSS out15 out10 VBIAS out5 out11 en_bb out6 out16 out12 out17 out7 net4 dac_thermo_top_2
**** begin user architecture code

.temp 25
.model adc_segmentation adc_segmentation
.control
 save all
 .options savecurrents
 .options method=gear
 .options reltol = 1e-4
 .options abstol=1e-12
 *.options rshunt=1e12
 *.options cshunt=1e-14
 pre_osdi /headless/iic_ihp/adc_segmentation.osdi
 tran 10u 205.121u 0
 set filetype=ascii
 write IGEN_DAC_TRAN.raw i(v18)
 write IGEN_DAC_TRAN.txt
 *dc V17 0 1.6 0.01
 *dc V1 1.2 1.2 0.01
 *set filetype=ascii
 *write IGEN_DAC_DC.raw
 *plot v(VBIAS)
 *plot i(V7)
 *plot i(V8)
 *plot i(V9)
 *plot @i0[current]
.endc
.include /foss/pdks/ihp-sg13g2/libs.ref/sg13g2_stdcell/spice/sg13g2_stdcell.spice
.lib /foss/pdks/ihp-sg13g2/libs.tech/ngspice/models/cornerMOSlv.lib mos_tt
.lib /foss/pdks/ihp-sg13g2/libs.tech/ngspice/models/cornerCAP.lib cap_typ
.lib /foss/pdks/ihp-sg13g2/libs.tech/ngspice/models/cornerRES.lib res_typ

**** end user architecture code
.ends

* expanding   symbol:  dac_thermo.sym # of pins=6
** sym_path: /home/designer/shared/current_generator/analog/DAC/dac_thermo.sym
** sch_path: /home/designer/shared/current_generator/analog/DAC/dac_thermo.sch
.subckt dac_thermo AVDD AVSS VBIAS enb DATA ISUM
*.PININFO AVDD:B AVSS:B VBIAS:B enb:B DATA:B ISUM:B
XM1 net1 VBIAS VS_cm AVDD sg13_lv_pmos w=0.72u l=3u ng=1 m=32
XM2 VBIAS enb AVDD AVDD sg13_lv_pmos w=0.360u l=2u ng=1 m=4
XM3 AVDD AVDD AVDD AVDD sg13_lv_pmos w=0.360u l=2u ng=1 m=4
x1 VS_cm DATA AVDD AVSS sg13g2_inv_1
V5 net1 ISUM 0
.ends

* expanding   symbol:  current_mirror.sym # of pins=7
** sym_path: /home/designer/shared/current_generator/analog/DAC/current_mirror.sym
** sch_path: /home/designer/shared/current_generator/analog/DAC/current_mirror.sch
.subckt current_mirror AVDD AVSS EN ENB SEL IREF IOUT
*.PININFO AVDD:B AVSS:B EN:B ENB:B SEL:B IREF:B IOUT:B
XM3 net15 EN AVSS AVSS sg13_lv_nmos w=2u l=2u ng=1 m=2
XM4 net16 EN AVSS AVSS sg13_lv_nmos w=2u l=2u ng=1 m=2
XM8 net1 SEL_IOUT net18 AVSS sg13_lv_nmos w=1u l=6u ng=1 m=1
x1 SELB EN SEL AVDD AVSS sg13g2_nand2_2
x2 SEL_IOUT SELB AVDD AVSS sg13g2_inv_1
XM35 IREF ENB AVSS AVSS sg13_lv_nmos w=2u l=2u ng=1 m=2
x3 IOUT net16 IREF AVSS current_mirror_nmos
x4 IREF net15 IREF AVSS current_mirror_nmos
x5 IOUT net17 IREF AVSS current_mirror_nmos
x6 IOUT net1 IREF AVSS current_mirror_nmos
x7 IOUT net2 IREF AVSS current_mirror_nmos
x8 IOUT net3 IREF AVSS current_mirror_nmos
x9 IOUT net4 IREF AVSS current_mirror_nmos
x10 IOUT net5 IREF AVSS current_mirror_nmos
x11 IOUT net6 IREF AVSS current_mirror_nmos
x12 IOUT net7 IREF AVSS current_mirror_nmos
x13 IOUT net8 IREF AVSS current_mirror_nmos
x14 IOUT net9 IREF AVSS current_mirror_nmos
x15 IOUT net10 IREF AVSS current_mirror_nmos
x16 IOUT net11 IREF AVSS current_mirror_nmos
x17 IOUT net12 IREF AVSS current_mirror_nmos
x18 IOUT net13 IREF AVSS current_mirror_nmos
x19 IOUT net14 IREF AVSS current_mirror_nmos
XM2 net18 SEL_IOUT AVSS AVSS sg13_lv_nmos w=1u l=6u ng=1 m=1
XM1 net17 SEL_IOUT net19 AVSS sg13_lv_nmos w=1u l=6u ng=1 m=1
XM6 net19 SEL_IOUT AVSS AVSS sg13_lv_nmos w=1u l=6u ng=1 m=1
XM5 net2 SEL_IOUT net20 AVSS sg13_lv_nmos w=1u l=6u ng=1 m=1
XM7 net20 SEL_IOUT AVSS AVSS sg13_lv_nmos w=1u l=6u ng=1 m=1
XM9 net3 SEL_IOUT net21 AVSS sg13_lv_nmos w=1u l=6u ng=1 m=1
XM10 net21 SEL_IOUT AVSS AVSS sg13_lv_nmos w=1u l=6u ng=1 m=1
XM11 net4 SEL_IOUT net22 AVSS sg13_lv_nmos w=1u l=6u ng=1 m=1
XM12 net22 SEL_IOUT AVSS AVSS sg13_lv_nmos w=1u l=6u ng=1 m=1
XM13 net5 SEL_IOUT net23 AVSS sg13_lv_nmos w=1u l=6u ng=1 m=1
XM14 net23 SEL_IOUT AVSS AVSS sg13_lv_nmos w=1u l=6u ng=1 m=1
XM15 net6 SEL_IOUT net24 AVSS sg13_lv_nmos w=1u l=6u ng=1 m=1
XM16 net24 SEL_IOUT AVSS AVSS sg13_lv_nmos w=1u l=6u ng=1 m=1
XM17 net7 SEL_IOUT net25 AVSS sg13_lv_nmos w=1u l=6u ng=1 m=1
XM18 net25 SEL_IOUT AVSS AVSS sg13_lv_nmos w=1u l=6u ng=1 m=1
XM19 net8 SEL_IOUT net26 AVSS sg13_lv_nmos w=1u l=6u ng=1 m=1
XM20 net26 SEL_IOUT AVSS AVSS sg13_lv_nmos w=1u l=6u ng=1 m=1
XM21 net9 SEL_IOUT net27 AVSS sg13_lv_nmos w=1u l=6u ng=1 m=1
XM22 net27 SEL_IOUT AVSS AVSS sg13_lv_nmos w=1u l=6u ng=1 m=1
XM23 net10 SEL_IOUT net28 AVSS sg13_lv_nmos w=1u l=6u ng=1 m=1
XM24 net28 SEL_IOUT AVSS AVSS sg13_lv_nmos w=1u l=6u ng=1 m=1
XM25 net11 SEL_IOUT net29 AVSS sg13_lv_nmos w=1u l=6u ng=1 m=1
XM26 net29 SEL_IOUT AVSS AVSS sg13_lv_nmos w=1u l=6u ng=1 m=1
XM27 net12 SEL_IOUT net30 AVSS sg13_lv_nmos w=1u l=6u ng=1 m=1
XM28 net30 SEL_IOUT AVSS AVSS sg13_lv_nmos w=1u l=6u ng=1 m=1
XM29 net13 SEL_IOUT net31 AVSS sg13_lv_nmos w=1u l=6u ng=1 m=1
XM30 net31 SEL_IOUT AVSS AVSS sg13_lv_nmos w=1u l=6u ng=1 m=1
XM31 net14 SEL_IOUT net32 AVSS sg13_lv_nmos w=1u l=6u ng=1 m=1
XM32 net32 SEL_IOUT AVSS AVSS sg13_lv_nmos w=1u l=6u ng=1 m=1
.ends

* expanding   symbol:  adc_segmentation.sym # of pins=20
** sym_path: /home/designer/shared/current_generator/analog/DAC/adc_segmentation.sym
** sch_path: /home/designer/shared/current_generator/analog/DAC/adc_segmentation.sch
.subckt adc_segmentation vin gnd out0 out10 out11 out1 out2 out12 out3 out13 out4 out14 out5 out15 out6 out16 out17 out7 out8 out9
+ model
model=adc_segmentation
*.PININFO vin:B gnd:B out0:B out1:B out2:B out3:B out4:B out5:B out6:B out7:B out8:B out9:B out10:B out11:B out12:B out13:B
*+ out14:B out15:B out16:B out17:B
.ends

* expanding   symbol:  non_overlap.sym # of pins=8
** sym_path: /home/designer/shared/current_generator/analog/DAC/non_overlap.sym
** sch_path: /home/designer/shared/current_generator/analog/DAC/non_overlap.sch
.subckt non_overlap AVDD AVSS in inb a b sign signb
*.PININFO AVDD:B AVSS:B in:B inb:B a:B b:B sign:B signb:B
x2 sign net1 AVDD AVSS sg13g2_inv_1
x1 net2 inb a AVDD AVSS sg13g2_nand2_2
x3 net1 in b AVDD AVSS sg13g2_nand2_2
x4 signb net2 AVDD AVSS sg13g2_inv_1
.ends

* expanding   symbol:  byn_dac.sym # of pins=8
** sym_path: /home/designer/shared/current_generator/analog/DAC/byn_dac.sym
** sch_path: /home/designer/shared/current_generator/analog/DAC/byn_dac.sch
.subckt byn_dac AVDD AVSS VBIAS enb DATA0 DATA1 DATA2 ISUM
*.PININFO AVDD:B AVSS:B VBIAS:B enb:B DATA1:B ISUM:B DATA0:B DATA2:B
x1 AVDD AVSS VBIAS enb DATA0 ISUM dac
x2 AVDD AVSS VBIAS enb DATA1 ISUM dac
x3 AVDD AVSS VBIAS enb DATA1 ISUM dac
x4 AVDD AVSS VBIAS enb DATA2 ISUM dac
x5 AVDD AVSS VBIAS enb DATA2 ISUM dac
x6 AVDD AVSS VBIAS enb DATA2 ISUM dac
x7 AVDD AVSS VBIAS enb DATA2 ISUM dac
.ends

* expanding   symbol:  dsw.sym # of pins=6
** sym_path: /home/designer/shared/current_generator/analog/DAC/dsw.sym
** sch_path: /home/designer/shared/current_generator/analog/DAC/dsw.sch
.subckt dsw SIGN SIGNB IN AVSS VOP VOM
*.PININFO SIGN:B SIGNB:B IN:B AVSS:B VOP:B VOM:B
XM1 IN SIGN VOM AVSS sg13_lv_nmos w=3u l=0.13u ng=1 m=2
XM2 VOM SIGNB AVSS AVSS sg13_lv_nmos w=3u l=0.13u ng=1 m=2
XM3 IN SIGNB VOP AVSS sg13_lv_nmos w=3u l=0.13u ng=1 m=2
XM4 VOP SIGN AVSS AVSS sg13_lv_nmos w=3u l=0.13u ng=1 m=2
.ends

* expanding   symbol:  dac_thermo_top_2.sym # of pins=20
** sym_path: /home/designer/shared/current_generator/analog/DAC/dac_thermo_top_2.sym
** sch_path: /home/designer/shared/current_generator/analog/DAC/dac_thermo_top_2.sch
.subckt dac_thermo_top_2 DATA8 AVDD DATA13 DATA3 DATA9 DATA4 DATA14 AVSS DATA15 DATA10 VBIAS DATA5 DATA11 en_bb DATA6 DATA16
+ DATA12 DATA17 DATA7 ISUM
*.PININFO AVDD:B AVSS:B VBIAS:B en_bb:B DATA4:B ISUM:B DATA3:B DATA5:B DATA7:B DATA6:B DATA8:B DATA9:B DATA10:B DATA12:B DATA11:B
*+ DATA13:B DATA14:B DATA15:B DATA16:B DATA17:B
x1[7] AVDD AVSS VBIAS enb DATA3 ISUM dac
x1[6] AVDD AVSS VBIAS enb DATA3 ISUM dac
x1[5] AVDD AVSS VBIAS enb DATA3 ISUM dac
x1[4] AVDD AVSS VBIAS enb DATA3 ISUM dac
x1[3] AVDD AVSS VBIAS enb DATA3 ISUM dac
x1[2] AVDD AVSS VBIAS enb DATA3 ISUM dac
x1[1] AVDD AVSS VBIAS enb DATA3 ISUM dac
x1[0] AVDD AVSS VBIAS enb DATA3 ISUM dac
x9[7] AVDD AVSS VBIAS enb DATA4 ISUM dac
x9[6] AVDD AVSS VBIAS enb DATA4 ISUM dac
x9[5] AVDD AVSS VBIAS enb DATA4 ISUM dac
x9[4] AVDD AVSS VBIAS enb DATA4 ISUM dac
x9[3] AVDD AVSS VBIAS enb DATA4 ISUM dac
x9[2] AVDD AVSS VBIAS enb DATA4 ISUM dac
x9[1] AVDD AVSS VBIAS enb DATA4 ISUM dac
x9[0] AVDD AVSS VBIAS enb DATA4 ISUM dac
x17[7] AVDD AVSS VBIAS enb DATA5 ISUM dac
x17[6] AVDD AVSS VBIAS enb DATA5 ISUM dac
x17[5] AVDD AVSS VBIAS enb DATA5 ISUM dac
x17[4] AVDD AVSS VBIAS enb DATA5 ISUM dac
x17[3] AVDD AVSS VBIAS enb DATA5 ISUM dac
x17[2] AVDD AVSS VBIAS enb DATA5 ISUM dac
x17[1] AVDD AVSS VBIAS enb DATA5 ISUM dac
x17[0] AVDD AVSS VBIAS enb DATA5 ISUM dac
x25[7] AVDD AVSS VBIAS enb DATA6 ISUM dac
x25[6] AVDD AVSS VBIAS enb DATA6 ISUM dac
x25[5] AVDD AVSS VBIAS enb DATA6 ISUM dac
x25[4] AVDD AVSS VBIAS enb DATA6 ISUM dac
x25[3] AVDD AVSS VBIAS enb DATA6 ISUM dac
x25[2] AVDD AVSS VBIAS enb DATA6 ISUM dac
x25[1] AVDD AVSS VBIAS enb DATA6 ISUM dac
x25[0] AVDD AVSS VBIAS enb DATA6 ISUM dac
x33[7] AVDD AVSS VBIAS enb DATA7 ISUM dac
x33[6] AVDD AVSS VBIAS enb DATA7 ISUM dac
x33[5] AVDD AVSS VBIAS enb DATA7 ISUM dac
x33[4] AVDD AVSS VBIAS enb DATA7 ISUM dac
x33[3] AVDD AVSS VBIAS enb DATA7 ISUM dac
x33[2] AVDD AVSS VBIAS enb DATA7 ISUM dac
x33[1] AVDD AVSS VBIAS enb DATA7 ISUM dac
x33[0] AVDD AVSS VBIAS enb DATA7 ISUM dac
x41[7] AVDD AVSS VBIAS enb DATA8 ISUM dac
x41[6] AVDD AVSS VBIAS enb DATA8 ISUM dac
x41[5] AVDD AVSS VBIAS enb DATA8 ISUM dac
x41[4] AVDD AVSS VBIAS enb DATA8 ISUM dac
x41[3] AVDD AVSS VBIAS enb DATA8 ISUM dac
x41[2] AVDD AVSS VBIAS enb DATA8 ISUM dac
x41[1] AVDD AVSS VBIAS enb DATA8 ISUM dac
x41[0] AVDD AVSS VBIAS enb DATA8 ISUM dac
x49[7] AVDD AVSS VBIAS enb DATA9 ISUM dac
x49[6] AVDD AVSS VBIAS enb DATA9 ISUM dac
x49[5] AVDD AVSS VBIAS enb DATA9 ISUM dac
x49[4] AVDD AVSS VBIAS enb DATA9 ISUM dac
x49[3] AVDD AVSS VBIAS enb DATA9 ISUM dac
x49[2] AVDD AVSS VBIAS enb DATA9 ISUM dac
x49[1] AVDD AVSS VBIAS enb DATA9 ISUM dac
x49[0] AVDD AVSS VBIAS enb DATA9 ISUM dac
x57[7] AVDD AVSS VBIAS enb DATA10 ISUM dac
x57[6] AVDD AVSS VBIAS enb DATA10 ISUM dac
x57[5] AVDD AVSS VBIAS enb DATA10 ISUM dac
x57[4] AVDD AVSS VBIAS enb DATA10 ISUM dac
x57[3] AVDD AVSS VBIAS enb DATA10 ISUM dac
x57[2] AVDD AVSS VBIAS enb DATA10 ISUM dac
x57[1] AVDD AVSS VBIAS enb DATA10 ISUM dac
x57[0] AVDD AVSS VBIAS enb DATA10 ISUM dac
x65[7] AVDD AVSS VBIAS enb DATA11 ISUM dac
x65[6] AVDD AVSS VBIAS enb DATA11 ISUM dac
x65[5] AVDD AVSS VBIAS enb DATA11 ISUM dac
x65[4] AVDD AVSS VBIAS enb DATA11 ISUM dac
x65[3] AVDD AVSS VBIAS enb DATA11 ISUM dac
x65[2] AVDD AVSS VBIAS enb DATA11 ISUM dac
x65[1] AVDD AVSS VBIAS enb DATA11 ISUM dac
x65[0] AVDD AVSS VBIAS enb DATA11 ISUM dac
x73[7] AVDD AVSS VBIAS enb DATA12 ISUM dac
x73[6] AVDD AVSS VBIAS enb DATA12 ISUM dac
x73[5] AVDD AVSS VBIAS enb DATA12 ISUM dac
x73[4] AVDD AVSS VBIAS enb DATA12 ISUM dac
x73[3] AVDD AVSS VBIAS enb DATA12 ISUM dac
x73[2] AVDD AVSS VBIAS enb DATA12 ISUM dac
x73[1] AVDD AVSS VBIAS enb DATA12 ISUM dac
x73[0] AVDD AVSS VBIAS enb DATA12 ISUM dac
x81[7] AVDD AVSS VBIAS enb DATA13 ISUM dac
x81[6] AVDD AVSS VBIAS enb DATA13 ISUM dac
x81[5] AVDD AVSS VBIAS enb DATA13 ISUM dac
x81[4] AVDD AVSS VBIAS enb DATA13 ISUM dac
x81[3] AVDD AVSS VBIAS enb DATA13 ISUM dac
x81[2] AVDD AVSS VBIAS enb DATA13 ISUM dac
x81[1] AVDD AVSS VBIAS enb DATA13 ISUM dac
x81[0] AVDD AVSS VBIAS enb DATA13 ISUM dac
x89[7] AVDD AVSS VBIAS enb DATA14 ISUM dac
x89[6] AVDD AVSS VBIAS enb DATA14 ISUM dac
x89[5] AVDD AVSS VBIAS enb DATA14 ISUM dac
x89[4] AVDD AVSS VBIAS enb DATA14 ISUM dac
x89[3] AVDD AVSS VBIAS enb DATA14 ISUM dac
x89[2] AVDD AVSS VBIAS enb DATA14 ISUM dac
x89[1] AVDD AVSS VBIAS enb DATA14 ISUM dac
x89[0] AVDD AVSS VBIAS enb DATA14 ISUM dac
x97[7] AVDD AVSS VBIAS enb DATA15 ISUM dac
x97[6] AVDD AVSS VBIAS enb DATA15 ISUM dac
x97[5] AVDD AVSS VBIAS enb DATA15 ISUM dac
x97[4] AVDD AVSS VBIAS enb DATA15 ISUM dac
x97[3] AVDD AVSS VBIAS enb DATA15 ISUM dac
x97[2] AVDD AVSS VBIAS enb DATA15 ISUM dac
x97[1] AVDD AVSS VBIAS enb DATA15 ISUM dac
x97[0] AVDD AVSS VBIAS enb DATA15 ISUM dac
x105[7] AVDD AVSS VBIAS enb DATA16 ISUM dac
x105[6] AVDD AVSS VBIAS enb DATA16 ISUM dac
x105[5] AVDD AVSS VBIAS enb DATA16 ISUM dac
x105[4] AVDD AVSS VBIAS enb DATA16 ISUM dac
x105[3] AVDD AVSS VBIAS enb DATA16 ISUM dac
x105[2] AVDD AVSS VBIAS enb DATA16 ISUM dac
x105[1] AVDD AVSS VBIAS enb DATA16 ISUM dac
x105[0] AVDD AVSS VBIAS enb DATA16 ISUM dac
x113[7] AVDD AVSS VBIAS enb DATA17 ISUM dac
x113[6] AVDD AVSS VBIAS enb DATA17 ISUM dac
x113[5] AVDD AVSS VBIAS enb DATA17 ISUM dac
x113[4] AVDD AVSS VBIAS enb DATA17 ISUM dac
x113[3] AVDD AVSS VBIAS enb DATA17 ISUM dac
x113[2] AVDD AVSS VBIAS enb DATA17 ISUM dac
x113[1] AVDD AVSS VBIAS enb DATA17 ISUM dac
x113[0] AVDD AVSS VBIAS enb DATA17 ISUM dac
.ends

* expanding   symbol:  current_mirror_nmos.sym # of pins=4
** sym_path: /home/designer/shared/current_generator/analog/DAC/current_mirror_nmos.sym
** sch_path: /home/designer/shared/current_generator/analog/DAC/current_mirror_nmos.sch
.subckt current_mirror_nmos D S G B
*.PININFO D:B S:B G:B B:B
XM2 D G net1 B sg13_lv_nmos w=2u l=2u ng=1 m=1
XM5 net1 G net9 B sg13_lv_nmos w=2u l=2u ng=1 m=1
XM6 net9 G net8 B sg13_lv_nmos w=2u l=2u ng=1 m=1
XM9 net8 G net2 B sg13_lv_nmos w=2u l=2u ng=1 m=1
XM11 net2 G net4 B sg13_lv_nmos w=2u l=2u ng=1 m=1
XM13 net4 G net3 B sg13_lv_nmos w=2u l=2u ng=1 m=1
XM15 net3 G net6 B sg13_lv_nmos w=2u l=2u ng=1 m=1
XM17 net6 G net5 B sg13_lv_nmos w=2u l=2u ng=1 m=1
XM19 net5 G net7 B sg13_lv_nmos w=2u l=2u ng=1 m=1
XM1 net7 G S B sg13_lv_nmos w=2u l=2u ng=1 m=1
.ends

* expanding   symbol:  dac.sym # of pins=6
** sym_path: /home/designer/shared/current_generator/analog/DAC/dac.sym
** sch_path: /home/designer/shared/current_generator/analog/DAC/dac.sch
.subckt dac AVDD AVSS VBIAS enb DATA ISUM
*.PININFO AVDD:B AVSS:B VBIAS:B enb:B DATA:B ISUM:B
XM1 ISUM VBIAS VS_cm AVDD sg13_lv_pmos w=0.72u l=3u ng=1 m=4
XM2 VBIAS enb AVDD AVDD sg13_lv_pmos w=0.360u l=2u ng=1 m=4
XM3 AVDD AVDD AVDD AVDD sg13_lv_pmos w=0.360u l=2u ng=1 m=4
x2 VS_cm DATA AVDD AVSS sg13g2_inv_1
.ends

.GLOBAL GND
