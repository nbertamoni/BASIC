** sch_path: /home/designer/shared/BASIC/current_generator/analog/DAC/schematics/inverter.sch
.subckt inverter A Y VDD VSS
*.PININFO Y:O A:I VDD:B VSS:B
MMN0 Y A VSS VSS sg13_lv_nmos w=740.00n l=130.00n ng=1
MMP0 Y A VDD VDD sg13_lv_pmos w=1.12u l=130.00n ng=1
.ends
