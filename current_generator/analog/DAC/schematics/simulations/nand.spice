** sch_path: /home/designer/shared/BASIC/current_generator/analog/DAC/schematics/nand.sch
.subckt nand VDD VSS A B Y
*.PININFO Y:O A:I VDD:B VSS:B B:I
MMN0 net1 B VSS VSS sg13_lv_nmos w=1.44u l=130.00n ng=2
MMP0 Y B VDD VDD sg13_lv_pmos w=2.24u l=130.00n ng=2
MMN1 Y A net1 VSS sg13_lv_nmos w=1.44u l=130.00n ng=2
MMP1 Y A VDD VDD sg13_lv_pmos w=2.24u l=130.00n ng=2
.ends
