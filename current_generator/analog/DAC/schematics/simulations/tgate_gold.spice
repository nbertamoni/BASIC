** sch_path: /home/designer/shared/BASIC/current_generator/analog/DAC/schematics/tgate_gold.sch
.subckt tgate_gold AVDD AVSS EN ENB A B
*.PININFO AVDD:B AVSS:B EN:B ENB:B A:B B:B
MM1 A EN B AVSS sg13_lv_nmos w=1u l=1u ng=1 m=2
MM2 B ENB A AVDD sg13_lv_pmos w=1u l=1u ng=1 m=2
.ends
