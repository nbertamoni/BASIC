** sch_path: /opt/pdks/ihp-sg13g2/libs.tech/xschem/sg13g2_stdcells/sg13g2_inv_1.sch
.subckt sg13g2_inv_1 Y A VDD VSS

*.PININFO Y:O A:I VDD:B VSS:B
MN0 Y A VSS VSS sg13_lv_nmos w=740.00n l=130.00n ng=1 m=1
MP0 Y A VDD VDD sg13_lv_pmos w=1.12u l=130.00n ng=1 m=1
.ends
