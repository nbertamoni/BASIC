** sch_path: /home/designer/shared/BASIC/current_generator/analog/DAC/schematics/current_mirror.sch
.subckt current_mirror AVDD AVSS EN ENB SEL IREF IOUT
*.PININFO AVDD:B AVSS:B EN:B ENB:B SEL:B IREF:B IOUT:B
MM3 sw_en_iref EN AVSS AVSS sg13_lv_nmos w=2u l=2u ng=1 m=2
MM4 sw_en_iout EN AVSS AVSS sg13_lv_nmos w=2u l=2u ng=1 m=2
MM8 sw_sel_iout_02 SEL_IOUT ssw_sel_iout_02 AVSS sg13_lv_nmos w=1u l=6u ng=1
MM35 IREF ENB AVSS AVSS sg13_lv_nmos w=2u l=2u ng=1 m=2
MM2 ssw_sel_iout_02 SEL_IOUT AVSS AVSS sg13_lv_nmos w=1u l=6u ng=1
MM1 sw_sel_iout_01 SEL_IOUT ssw_sel_iout_01 AVSS sg13_lv_nmos w=1u l=6u ng=1
MM6 ssw_sel_iout_01 SEL_IOUT AVSS AVSS sg13_lv_nmos w=1u l=6u ng=1
MM5 sw_sel_iout_03 SEL_IOUT ssw_sel_iout_03 AVSS sg13_lv_nmos w=1u l=6u ng=1
MM7 ssw_sel_iout_03 SEL_IOUT AVSS AVSS sg13_lv_nmos w=1u l=6u ng=1
MM9 sw_sel_iout_04 SEL_IOUT ssw_sel_iout_04 AVSS sg13_lv_nmos w=1u l=6u ng=1
MM10 ssw_sel_iout_04 SEL_IOUT AVSS AVSS sg13_lv_nmos w=1u l=6u ng=1
MM11 sw_sel_iout_05 SEL_IOUT ssw_sel_iout_05 AVSS sg13_lv_nmos w=1u l=6u ng=1
MM12 ssw_sel_iout_05 SEL_IOUT AVSS AVSS sg13_lv_nmos w=1u l=6u ng=1
MM13 sw_sel_iout_06 SEL_IOUT ssw_sel_iout_06 AVSS sg13_lv_nmos w=1u l=6u ng=1
MM14 ssw_sel_iout_06 SEL_IOUT AVSS AVSS sg13_lv_nmos w=1u l=6u ng=1
MM15 sw_sel_iout_07 SEL_IOUT ssw_sel_iout_07 AVSS sg13_lv_nmos w=1u l=6u ng=1
MM16 ssw_sel_iout_07 SEL_IOUT AVSS AVSS sg13_lv_nmos w=1u l=6u ng=1
MM17 sw_sel_iout_08 SEL_IOUT ssw_sel_iout_08 AVSS sg13_lv_nmos w=1u l=6u ng=1
MM18 ssw_sel_iout_08 SEL_IOUT AVSS AVSS sg13_lv_nmos w=1u l=6u ng=1
MM19 sw_sel_iout_09 SEL_IOUT ssw_sel_iout_09 AVSS sg13_lv_nmos w=1u l=6u ng=1
MM20 ssw_sel_iout_09 SEL_IOUT AVSS AVSS sg13_lv_nmos w=1u l=6u ng=1
MM21 sw_sel_iout_10 SEL_IOUT ssw_sel_iout_10 AVSS sg13_lv_nmos w=1u l=6u ng=1
MM22 ssw_sel_iout_10 SEL_IOUT AVSS AVSS sg13_lv_nmos w=1u l=6u ng=1
MM23 sw_sel_iout_11 SEL_IOUT ssw_sel_iout_11 AVSS sg13_lv_nmos w=1u l=6u ng=1
MM24 ssw_sel_iout_11 SEL_IOUT AVSS AVSS sg13_lv_nmos w=1u l=6u ng=1
MM25 sw_sel_iout_12 SEL_IOUT ssw_sel_iout_12 AVSS sg13_lv_nmos w=1u l=6u ng=1
MM26 ssw_sel_iout_12 SEL_IOUT AVSS AVSS sg13_lv_nmos w=1u l=6u ng=1
MM27 sw_sel_iout_13 SEL_IOUT ssw_sel_iout_13 AVSS sg13_lv_nmos w=1u l=6u ng=1
MM28 ssw_sel_iout_13 SEL_IOUT AVSS AVSS sg13_lv_nmos w=1u l=6u ng=1
MM29 sw_sel_iout_14 SEL_IOUT ssw_sel_iout_14 AVSS sg13_lv_nmos w=1u l=6u ng=1
MM30 ssw_sel_iout_14 SEL_IOUT AVSS AVSS sg13_lv_nmos w=1u l=6u ng=1
MM31 sw_sel_iout_15 SEL_IOUT ssw_sel_iout_15 AVSS sg13_lv_nmos w=1u l=6u ng=1
MM32 ssw_sel_iout_15 SEL_IOUT AVSS AVSS sg13_lv_nmos w=1u l=6u ng=1
x20 SELB SEL_IOUT AVDD AVSS inverter
x21 AVDD AVSS EN SEL SELB nand
MM33 IOUT IREF x01_i AVSS sg13_lv_nmos w=2u l=2u ng=1
MM34 x01_i IREF x01_h AVSS sg13_lv_nmos w=2u l=2u ng=1
MM36 x01_h IREF x01_g AVSS sg13_lv_nmos w=2u l=2u ng=1
MM37 x01_g IREF x01_f AVSS sg13_lv_nmos w=2u l=2u ng=1
MM38 x01_f IREF x01_e AVSS sg13_lv_nmos w=2u l=2u ng=1
MM39 x01_e IREF x01_d AVSS sg13_lv_nmos w=2u l=2u ng=1
MM40 x01_d IREF x01_c AVSS sg13_lv_nmos w=2u l=2u ng=1
MM41 x01_c IREF x01_b AVSS sg13_lv_nmos w=2u l=2u ng=1
MM42 x01_b IREF x01_a AVSS sg13_lv_nmos w=2u l=2u ng=1
MM43 x01_a IREF sw_sel_iout_01 AVSS sg13_lv_nmos w=2u l=2u ng=1
MM44 IOUT IREF x02_i AVSS sg13_lv_nmos w=2u l=2u ng=1
MM45 x02_i IREF x02_h AVSS sg13_lv_nmos w=2u l=2u ng=1
MM46 x02_h IREF x02_g AVSS sg13_lv_nmos w=2u l=2u ng=1
MM47 x02_g IREF x02_f AVSS sg13_lv_nmos w=2u l=2u ng=1
MM48 x02_f IREF x02_e AVSS sg13_lv_nmos w=2u l=2u ng=1
MM49 x02_e IREF x02_d AVSS sg13_lv_nmos w=2u l=2u ng=1
MM50 x02_d IREF x02_c AVSS sg13_lv_nmos w=2u l=2u ng=1
MM51 x02_c IREF x02_b AVSS sg13_lv_nmos w=2u l=2u ng=1
MM52 x02_b IREF x02_a AVSS sg13_lv_nmos w=2u l=2u ng=1
MM53 x02_a IREF sw_sel_iout_02 AVSS sg13_lv_nmos w=2u l=2u ng=1
MM54 IOUT IREF x03_i AVSS sg13_lv_nmos w=2u l=2u ng=1
MM55 x03_i IREF x03_h AVSS sg13_lv_nmos w=2u l=2u ng=1
MM56 x03_h IREF x03_g AVSS sg13_lv_nmos w=2u l=2u ng=1
MM57 x03_g IREF x03_f AVSS sg13_lv_nmos w=2u l=2u ng=1
MM58 x03_f IREF x03_e AVSS sg13_lv_nmos w=2u l=2u ng=1
MM59 x03_e IREF x03_d AVSS sg13_lv_nmos w=2u l=2u ng=1
MM60 x03_d IREF x03_c AVSS sg13_lv_nmos w=2u l=2u ng=1
MM61 x03_c IREF x03_b AVSS sg13_lv_nmos w=2u l=2u ng=1
MM62 x03_b IREF x03_a AVSS sg13_lv_nmos w=2u l=2u ng=1
MM63 x03_a IREF sw_sel_iout_03 AVSS sg13_lv_nmos w=2u l=2u ng=1
MM64 IOUT IREF x04_i AVSS sg13_lv_nmos w=2u l=2u ng=1
MM65 x04_i IREF x04_h AVSS sg13_lv_nmos w=2u l=2u ng=1
MM66 x04_h IREF x04_g AVSS sg13_lv_nmos w=2u l=2u ng=1
MM67 x04_g IREF x04_f AVSS sg13_lv_nmos w=2u l=2u ng=1
MM68 x04_f IREF x04_e AVSS sg13_lv_nmos w=2u l=2u ng=1
MM69 x04_e IREF x04_d AVSS sg13_lv_nmos w=2u l=2u ng=1
MM70 x04_d IREF x04_c AVSS sg13_lv_nmos w=2u l=2u ng=1
MM71 x04_c IREF x04_b AVSS sg13_lv_nmos w=2u l=2u ng=1
MM72 x04_b IREF x04_a AVSS sg13_lv_nmos w=2u l=2u ng=1
MM73 x04_a IREF sw_sel_iout_04 AVSS sg13_lv_nmos w=2u l=2u ng=1
MM74 IOUT IREF x05_i AVSS sg13_lv_nmos w=2u l=2u ng=1
MM75 x05_i IREF x05_h AVSS sg13_lv_nmos w=2u l=2u ng=1
MM76 x05_h IREF x05_g AVSS sg13_lv_nmos w=2u l=2u ng=1
MM77 x05_g IREF x05_f AVSS sg13_lv_nmos w=2u l=2u ng=1
MM78 x05_f IREF x05_e AVSS sg13_lv_nmos w=2u l=2u ng=1
MM79 x05_e IREF x05_d AVSS sg13_lv_nmos w=2u l=2u ng=1
MM80 x05_d IREF x05_c AVSS sg13_lv_nmos w=2u l=2u ng=1
MM81 x05_c IREF x05_b AVSS sg13_lv_nmos w=2u l=2u ng=1
MM82 x05_b IREF x05_a AVSS sg13_lv_nmos w=2u l=2u ng=1
MM83 x05_a IREF sw_sel_iout_05 AVSS sg13_lv_nmos w=2u l=2u ng=1
MM84 IOUT IREF x06_i AVSS sg13_lv_nmos w=2u l=2u ng=1
MM85 x06_i IREF x06_h AVSS sg13_lv_nmos w=2u l=2u ng=1
MM86 x06_h IREF x06_g AVSS sg13_lv_nmos w=2u l=2u ng=1
MM87 x06_g IREF x06_f AVSS sg13_lv_nmos w=2u l=2u ng=1
MM88 x06_f IREF x06_e AVSS sg13_lv_nmos w=2u l=2u ng=1
MM89 x06_e IREF x06_d AVSS sg13_lv_nmos w=2u l=2u ng=1
MM90 x06_d IREF x06_c AVSS sg13_lv_nmos w=2u l=2u ng=1
MM91 x06_c IREF x06_b AVSS sg13_lv_nmos w=2u l=2u ng=1
MM92 x06_b IREF x06_a AVSS sg13_lv_nmos w=2u l=2u ng=1
MM93 x06_a IREF sw_sel_iout_06 AVSS sg13_lv_nmos w=2u l=2u ng=1
MM94 IOUT IREF x07_i AVSS sg13_lv_nmos w=2u l=2u ng=1
MM95 x07_i IREF x07_h AVSS sg13_lv_nmos w=2u l=2u ng=1
MM96 x07_h IREF x07_g AVSS sg13_lv_nmos w=2u l=2u ng=1
MM97 x07_g IREF x07_f AVSS sg13_lv_nmos w=2u l=2u ng=1
MM98 x07_f IREF x07_e AVSS sg13_lv_nmos w=2u l=2u ng=1
MM99 x07_e IREF x07_d AVSS sg13_lv_nmos w=2u l=2u ng=1
MM100 x07_d IREF x07_c AVSS sg13_lv_nmos w=2u l=2u ng=1
MM101 x07_c IREF x07_b AVSS sg13_lv_nmos w=2u l=2u ng=1
MM102 x07_b IREF x07_a AVSS sg13_lv_nmos w=2u l=2u ng=1
MM103 x07_a IREF sw_sel_iout_07 AVSS sg13_lv_nmos w=2u l=2u ng=1
MM104 IOUT IREF x08_i AVSS sg13_lv_nmos w=2u l=2u ng=1
MM105 x08_i IREF x08_h AVSS sg13_lv_nmos w=2u l=2u ng=1
MM106 x08_h IREF x08_g AVSS sg13_lv_nmos w=2u l=2u ng=1
MM107 x08_g IREF x08_f AVSS sg13_lv_nmos w=2u l=2u ng=1
MM108 x08_f IREF x08_e AVSS sg13_lv_nmos w=2u l=2u ng=1
MM109 x08_e IREF x08_d AVSS sg13_lv_nmos w=2u l=2u ng=1
MM110 x08_d IREF x08_c AVSS sg13_lv_nmos w=2u l=2u ng=1
MM111 x08_c IREF x08_b AVSS sg13_lv_nmos w=2u l=2u ng=1
MM112 x08_b IREF x08_a AVSS sg13_lv_nmos w=2u l=2u ng=1
MM113 x08_a IREF sw_sel_iout_08 AVSS sg13_lv_nmos w=2u l=2u ng=1
MM114 IOUT IREF x09_i AVSS sg13_lv_nmos w=2u l=2u ng=1
MM115 x09_i IREF x09_h AVSS sg13_lv_nmos w=2u l=2u ng=1
MM116 x09_h IREF x09_g AVSS sg13_lv_nmos w=2u l=2u ng=1
MM117 x09_g IREF x09_f AVSS sg13_lv_nmos w=2u l=2u ng=1
MM118 x09_f IREF x09_e AVSS sg13_lv_nmos w=2u l=2u ng=1
MM119 x09_e IREF x09_d AVSS sg13_lv_nmos w=2u l=2u ng=1
MM120 x09_d IREF x09_c AVSS sg13_lv_nmos w=2u l=2u ng=1
MM121 x09_c IREF x09_b AVSS sg13_lv_nmos w=2u l=2u ng=1
MM122 x09_b IREF x09_a AVSS sg13_lv_nmos w=2u l=2u ng=1
MM123 x09_a IREF sw_sel_iout_09 AVSS sg13_lv_nmos w=2u l=2u ng=1
MM124 IOUT IREF x10_i AVSS sg13_lv_nmos w=2u l=2u ng=1
MM125 x10_i IREF x10_h AVSS sg13_lv_nmos w=2u l=2u ng=1
MM126 x10_h IREF x10_g AVSS sg13_lv_nmos w=2u l=2u ng=1
MM127 x10_g IREF x10_f AVSS sg13_lv_nmos w=2u l=2u ng=1
MM128 x10_f IREF x10_e AVSS sg13_lv_nmos w=2u l=2u ng=1
MM129 x10_e IREF x10_d AVSS sg13_lv_nmos w=2u l=2u ng=1
MM130 x10_d IREF x10_c AVSS sg13_lv_nmos w=2u l=2u ng=1
MM131 x10_c IREF x10_b AVSS sg13_lv_nmos w=2u l=2u ng=1
MM132 x10_b IREF x10_a AVSS sg13_lv_nmos w=2u l=2u ng=1
MM133 x10_a IREF sw_sel_iout_10 AVSS sg13_lv_nmos w=2u l=2u ng=1
MM134 IOUT IREF x11_i AVSS sg13_lv_nmos w=2u l=2u ng=1
MM135 x11_i IREF x11_h AVSS sg13_lv_nmos w=2u l=2u ng=1
MM136 x11_h IREF x11_g AVSS sg13_lv_nmos w=2u l=2u ng=1
MM137 x11_g IREF x11_f AVSS sg13_lv_nmos w=2u l=2u ng=1
MM138 x11_f IREF x11_e AVSS sg13_lv_nmos w=2u l=2u ng=1
MM139 x11_e IREF x11_d AVSS sg13_lv_nmos w=2u l=2u ng=1
MM140 x11_d IREF x11_c AVSS sg13_lv_nmos w=2u l=2u ng=1
MM141 x11_c IREF x11_b AVSS sg13_lv_nmos w=2u l=2u ng=1
MM142 x11_b IREF x11_a AVSS sg13_lv_nmos w=2u l=2u ng=1
MM143 x11_a IREF sw_sel_iout_11 AVSS sg13_lv_nmos w=2u l=2u ng=1
MM144 IOUT IREF x12_i AVSS sg13_lv_nmos w=2u l=2u ng=1
MM145 x12_i IREF x12_h AVSS sg13_lv_nmos w=2u l=2u ng=1
MM146 x12_h IREF x12_g AVSS sg13_lv_nmos w=2u l=2u ng=1
MM147 x12_g IREF x12_f AVSS sg13_lv_nmos w=2u l=2u ng=1
MM148 x12_f IREF x12_e AVSS sg13_lv_nmos w=2u l=2u ng=1
MM149 x12_e IREF x12_d AVSS sg13_lv_nmos w=2u l=2u ng=1
MM150 x12_d IREF x12_c AVSS sg13_lv_nmos w=2u l=2u ng=1
MM151 x12_c IREF x12_b AVSS sg13_lv_nmos w=2u l=2u ng=1
MM152 x12_b IREF x12_a AVSS sg13_lv_nmos w=2u l=2u ng=1
MM153 x12_a IREF sw_sel_iout_12 AVSS sg13_lv_nmos w=2u l=2u ng=1
MM154 IOUT IREF x13_i AVSS sg13_lv_nmos w=2u l=2u ng=1
MM155 x13_i IREF x13_h AVSS sg13_lv_nmos w=2u l=2u ng=1
MM156 x13_h IREF x13_g AVSS sg13_lv_nmos w=2u l=2u ng=1
MM157 x13_g IREF x13_f AVSS sg13_lv_nmos w=2u l=2u ng=1
MM158 x13_f IREF x13_e AVSS sg13_lv_nmos w=2u l=2u ng=1
MM159 x13_e IREF x13_d AVSS sg13_lv_nmos w=2u l=2u ng=1
MM160 x13_d IREF x13_c AVSS sg13_lv_nmos w=2u l=2u ng=1
MM161 x13_c IREF x13_b AVSS sg13_lv_nmos w=2u l=2u ng=1
MM162 x13_b IREF x13_a AVSS sg13_lv_nmos w=2u l=2u ng=1
MM163 x13_a IREF sw_sel_iout_13 AVSS sg13_lv_nmos w=2u l=2u ng=1
MM164 IOUT IREF x14_i AVSS sg13_lv_nmos w=2u l=2u ng=1
MM165 x14_i IREF x14_h AVSS sg13_lv_nmos w=2u l=2u ng=1
MM166 x14_h IREF x14_g AVSS sg13_lv_nmos w=2u l=2u ng=1
MM167 x14_g IREF x14_f AVSS sg13_lv_nmos w=2u l=2u ng=1
MM168 x14_f IREF x14_e AVSS sg13_lv_nmos w=2u l=2u ng=1
MM169 x14_e IREF x14_d AVSS sg13_lv_nmos w=2u l=2u ng=1
MM170 x14_d IREF x14_c AVSS sg13_lv_nmos w=2u l=2u ng=1
MM171 x14_c IREF x14_b AVSS sg13_lv_nmos w=2u l=2u ng=1
MM172 x14_b IREF x14_a AVSS sg13_lv_nmos w=2u l=2u ng=1
MM173 x14_a IREF sw_sel_iout_14 AVSS sg13_lv_nmos w=2u l=2u ng=1
MM174 IOUT IREF x15_i AVSS sg13_lv_nmos w=2u l=2u ng=1
MM175 x15_i IREF x15_h AVSS sg13_lv_nmos w=2u l=2u ng=1
MM176 x15_h IREF x15_g AVSS sg13_lv_nmos w=2u l=2u ng=1
MM177 x15_g IREF x15_f AVSS sg13_lv_nmos w=2u l=2u ng=1
MM178 x15_f IREF x15_e AVSS sg13_lv_nmos w=2u l=2u ng=1
MM179 x15_e IREF x15_d AVSS sg13_lv_nmos w=2u l=2u ng=1
MM180 x15_d IREF x15_c AVSS sg13_lv_nmos w=2u l=2u ng=1
MM181 x15_c IREF x15_b AVSS sg13_lv_nmos w=2u l=2u ng=1
MM182 x15_b IREF x15_a AVSS sg13_lv_nmos w=2u l=2u ng=1
MM183 x15_a IREF sw_sel_iout_15 AVSS sg13_lv_nmos w=2u l=2u ng=1
MM184 IREF IREF iref_i AVSS sg13_lv_nmos w=2u l=2u ng=1
MM185 iref_i IREF iref_h AVSS sg13_lv_nmos w=2u l=2u ng=1
MM186 iref_h IREF iref_g AVSS sg13_lv_nmos w=2u l=2u ng=1
MM187 iref_g IREF iref_f AVSS sg13_lv_nmos w=2u l=2u ng=1
MM188 iref_f IREF iref_e AVSS sg13_lv_nmos w=2u l=2u ng=1
MM189 iref_e IREF iref_d AVSS sg13_lv_nmos w=2u l=2u ng=1
MM190 iref_d IREF iref_c AVSS sg13_lv_nmos w=2u l=2u ng=1
MM191 iref_c IREF iref_b AVSS sg13_lv_nmos w=2u l=2u ng=1
MM192 iref_b IREF iref_a AVSS sg13_lv_nmos w=2u l=2u ng=1
MM193 iref_a IREF sw_en_iref AVSS sg13_lv_nmos w=2u l=2u ng=1
MM194 IOUT IREF iout_i AVSS sg13_lv_nmos w=2u l=2u ng=1
MM195 iout_i IREF iout_h AVSS sg13_lv_nmos w=2u l=2u ng=1
MM196 iout_h IREF iout_g AVSS sg13_lv_nmos w=2u l=2u ng=1
MM197 iout_g IREF iout_f AVSS sg13_lv_nmos w=2u l=2u ng=1
MM198 iout_f IREF iout_e AVSS sg13_lv_nmos w=2u l=2u ng=1
MM199 iout_e IREF iout_d AVSS sg13_lv_nmos w=2u l=2u ng=1
MM200 iout_d IREF iout_c AVSS sg13_lv_nmos w=2u l=2u ng=1
MM201 iout_c IREF iout_b AVSS sg13_lv_nmos w=2u l=2u ng=1
MM202 iout_b IREF iout_a AVSS sg13_lv_nmos w=2u l=2u ng=1
MM203 iout_a IREF sw_en_iout AVSS sg13_lv_nmos w=2u l=2u ng=1
MM204 AVSS AVSS AVSS AVSS sg13_lv_nmos w=2u l=2u ng=1 m=96
.ends

* expanding   symbol:  inverter.sym # of pins=4
** sym_path: /home/designer/shared/BASIC/current_generator/analog/DAC/schematics/inverter.sym
** sch_path: /home/designer/shared/BASIC/current_generator/analog/DAC/schematics/inverter.sch
.subckt inverter A Y VDD VSS
*.PININFO Y:O A:I VDD:B VSS:B
MMN0 Y A VSS VSS sg13_lv_nmos w=740.00n l=130.00n ng=1
MMP0 Y A VDD VDD sg13_lv_pmos w=1.12u l=130.00n ng=1
.ends

* expanding   symbol:  nand.sym # of pins=5
** sym_path: /home/designer/shared/BASIC/current_generator/analog/DAC/schematics/nand.sym
** sch_path: /home/designer/shared/BASIC/current_generator/analog/DAC/schematics/nand.sch
.subckt nand VDD VSS A B Y
*.PININFO Y:O A:I VDD:B VSS:B B:I
MMN0 net1 B VSS VSS sg13_lv_nmos w=1.44u l=130.00n ng=2
MMP0 Y B VDD VDD sg13_lv_pmos w=2.24u l=130.00n ng=2
MMN1 Y A net1 VSS sg13_lv_nmos w=1.44u l=130.00n ng=2
MMP1 Y A VDD VDD sg13_lv_pmos w=2.24u l=130.00n ng=2
.ends
