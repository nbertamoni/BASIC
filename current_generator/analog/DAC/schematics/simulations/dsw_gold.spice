** sch_path: /home/designer/shared/BASIC/current_generator/analog/DAC/schematics/dsw_gold.sch
.subckt dsw_gold SIGN SIGNB IN AVSS VOP VOM
*.PININFO SIGN:B SIGNB:B IN:B AVSS:B VOP:B VOM:B
MM1 IN SIGN VOM AVSS sg13_lv_nmos w=3u l=0.13u ng=1 m=2
MM2 VOM SIGNB AVSS AVSS sg13_lv_nmos w=3u l=0.13u ng=1 m=2
MM3 IN SIGNB VOP AVSS sg13_lv_nmos w=3u l=0.13u ng=1 m=2
MM4 VOP SIGN AVSS AVSS sg13_lv_nmos w=3u l=0.13u ng=1 m=2
.ends
